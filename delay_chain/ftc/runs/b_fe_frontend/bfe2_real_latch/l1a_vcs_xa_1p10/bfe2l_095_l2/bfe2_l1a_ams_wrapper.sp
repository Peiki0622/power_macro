* B-FE2-L1A VCS-XA wrapper; scenario=BFE2L-095-L2.
* VCS digital safe_d/latch_g ports are converted at this cell boundary.
* safe_d data is restored to exactly 0.95 V; latch PD_SAFE is 1.10 V.
.SUBCKT bfe2_l1a_ams \
+ safe_d_0 \
+safe_d_1 \
+safe_d_2 \
+safe_d_3 \
+safe_d_4 \
+safe_d_5 \
+safe_d_6 \
+safe_d_7 \
+safe_d_8 \
+safe_d_9 \
+safe_d_10 \
+safe_d_11 \
+safe_d_12 \
+safe_d_13 \
+safe_d_14 \
+safe_d_15 \
+safe_d_16 \
+safe_d_17 \
+safe_d_18 \
+safe_d_19 \
+safe_d_20 \
+safe_d_21 \
+safe_d_22 \
+safe_d_23 \
+safe_d_24 \
+safe_d_25 \
+safe_d_26 \
+safe_d_27 \
+safe_d_28 \
+safe_d_29 \
+latch_g \
+q_0 \
+q_1 \
+q_2 \
+q_3 \
+q_4 \
+q_5 \
+q_6 \
+q_7 \
+q_8 \
+q_9 \
+q_10 \
+q_11 \
+q_12 \
+q_13 \
+q_14 \
+q_15 \
+q_16 \
+q_17 \
+q_18 \
+q_19 \
+q_20 \
+q_21 \
+q_22 \
+q_23 \
+q_24 \
+q_25 \
+q_26 \
+q_27 \
+q_28 \
+q_29
* Frozen source-domain reference probes (not live transistor sensing).
V_VDD_SENSE vdd_sense 0 PWL(0.000000000000e+00 9.500000000000e-01 1.000000000000e-12 9.500000000000e-01 2.000000000000e-12 9.500000000000e-01 5.200000000000e-12 9.500000000000e-01 1.544000000000e-11 9.500000000000e-01 4.820800000000e-11 9.500000000000e-01 1.530656000000e-10 9.500000000000e-01 4.886099000000e-10 9.500000000000e-01 8.386099000000e-10 9.500000000000e-01 9.995000000000e-10 9.500000000000e-01 9.996500000000e-10 9.500000000000e-01 1.000130000000e-09 9.500000000000e-01 1.000271000000e-09 9.500000000000e-01 1.000500000000e-09 9.500000000000e-01 1.000549000000e-09 9.500000000000e-01 1.000579000000e-09 9.500000000000e-01 1.000674000000e-09 9.500000000000e-01 1.000921000000e-09 9.500000000000e-01 1.001177000000e-09 9.500000000000e-01 1.001636000000e-09 9.500000000000e-01 1.002995000000e-09 9.500000000000e-01 1.004717000000e-09 9.500000000000e-01 1.007157000000e-09 9.500000000000e-01 1.009530000000e-09 9.500000000000e-01 1.012064000000e-09 9.500000000000e-01 1.014479000000e-09 9.500000000000e-01 1.016999000000e-09 9.500000000000e-01 1.019780000000e-09 9.500000000000e-01 1.023006000000e-09 9.500000000000e-01 1.025715000000e-09 9.500000000000e-01 1.028767000000e-09 9.500000000000e-01 1.031545000000e-09 9.500000000000e-01 1.034548000000e-09 9.500000000000e-01 1.037295000000e-09 9.500000000000e-01 1.040188000000e-09 9.500000000000e-01 1.042931000000e-09 9.500000000000e-01 1.046095000000e-09 9.500000000000e-01 1.049020000000e-09 9.500000000000e-01 1.051920000000e-09 9.500000000000e-01 1.055268000000e-09 9.500000000000e-01 1.057963000000e-09 9.500000000000e-01 1.059420000000e-09 9.500000000000e-01 1.060877000000e-09 9.500000000000e-01 1.063981000000e-09 9.500000000000e-01 1.066813000000e-09 9.500000000000e-01 1.069715000000e-09 9.500000000000e-01 1.073141000000e-09 9.500000000000e-01 1.075000000000e-09 9.500000000000e-01 1.075500000000e-09 9.050000000000e-01 1.075834000000e-09 8.749579000000e-01 1.076000000000e-09 8.600000000000e-01 1.076266000000e-09 8.600000000000e-01 1.076419000000e-09 8.600000000000e-01 1.076822000000e-09 8.600000000000e-01 1.078112000000e-09 8.600000000000e-01 1.079915000000e-09 8.600000000000e-01 1.082834000000e-09 8.600000000000e-01 1.086452000000e-09 8.600000000000e-01 1.089863000000e-09 8.600000000000e-01 1.094093000000e-09 8.600000000000e-01 1.097558000000e-09 8.600000000000e-01 1.101264000000e-09 8.600000000000e-01 1.105520000000e-09 8.600000000000e-01 1.109056000000e-09 8.600000000000e-01 1.112992000000e-09 8.600000000000e-01 1.115807000000e-09 8.600000000000e-01 1.118621000000e-09 8.600000000000e-01 1.121942000000e-09 8.600000000000e-01 1.125724000000e-09 8.600000000000e-01 1.129501000000e-09 8.600000000000e-01 1.133249000000e-09 8.600000000000e-01 1.135809000000e-09 8.600000000000e-01 1.138369000000e-09 8.600000000000e-01 1.141791000000e-09 8.600000000000e-01 1.145734000000e-09 8.600000000000e-01 1.150017000000e-09 8.600000000000e-01 1.153865000000e-09 8.600000000000e-01 1.158361000000e-09 8.600000000000e-01 1.161824000000e-09 8.600000000000e-01 1.165535000000e-09 8.600000000000e-01 1.169527000000e-09 8.600000000000e-01 1.173109000000e-09 8.600000000000e-01 1.177056000000e-09 8.600000000000e-01 1.179535000000e-09 8.600000000000e-01 1.182013000000e-09 8.600000000000e-01 1.185429000000e-09 8.600000000000e-01 1.189651000000e-09 8.600000000000e-01 1.193349000000e-09 8.600000000000e-01 1.197208000000e-09 8.600000000000e-01 1.200595000000e-09 8.600000000000e-01 1.204042000000e-09 8.600000000000e-01 1.207661000000e-09 8.600000000000e-01 1.212044000000e-09 8.600000000000e-01 1.215603000000e-09 8.600000000000e-01 1.219624000000e-09 8.600000000000e-01 1.222280000000e-09 8.600000000000e-01 1.224935000000e-09 8.600000000000e-01 1.228316000000e-09 8.600000000000e-01 1.229186000000e-09 8.600000000000e-01 1.230042000000e-09 8.600000000000e-01 1.232779000000e-09 8.600000000000e-01 1.235670000000e-09 8.600000000000e-01 1.238863000000e-09 8.600000000000e-01 1.243639000000e-09 8.600000000000e-01 1.246999000000e-09 8.600000000000e-01 1.250850000000e-09 8.600000000000e-01 1.255187000000e-09 8.600000000000e-01 1.258822000000e-09 8.600000000000e-01 1.259631000000e-09 8.600000000000e-01 1.260438000000e-09 8.600000000000e-01 1.263021000000e-09 8.600000000000e-01 1.265957000000e-09 8.600000000000e-01 1.269137000000e-09 8.600000000000e-01 1.273131000000e-09 8.600000000000e-01 1.276658000000e-09 8.600000000000e-01 1.280195000000e-09 8.600000000000e-01 1.284359000000e-09 8.600000000000e-01 1.288216000000e-09 8.600000000000e-01 1.291735000000e-09 8.600000000000e-01 1.292574000000e-09 8.600000000000e-01 1.293423000000e-09 8.600000000000e-01 1.296139000000e-09 8.600000000000e-01 1.299136000000e-09 8.600000000000e-01 1.302736000000e-09 8.600000000000e-01 1.306959000000e-09 8.600000000000e-01 1.310392000000e-09 8.600000000000e-01 1.314112000000e-09 8.600000000000e-01 1.317424000000e-09 8.600000000000e-01 1.320972000000e-09 8.600000000000e-01 1.324632000000e-09 8.600000000000e-01 1.327145000000e-09 8.600000000000e-01 1.329658000000e-09 8.600000000000e-01 1.333049000000e-09 8.600000000000e-01 1.337028000000e-09 8.600000000000e-01 1.341293000000e-09 8.600000000000e-01 1.345153000000e-09 8.600000000000e-01 1.349994000000e-09 8.600000000000e-01 1.353616000000e-09 8.600000000000e-01 1.357116000000e-09 8.600000000000e-01 1.357983000000e-09 8.600000000000e-01 1.358962000000e-09 8.600000000000e-01 1.362092000000e-09 8.600000000000e-01 1.364885000000e-09 8.600000000000e-01 1.369987000000e-09 8.600000000000e-01 1.373500000000e-09 8.600000000000e-01 1.377230000000e-09 8.600000000000e-01 1.381288000000e-09 8.600000000000e-01 1.384815000000e-09 8.600000000000e-01 1.388662000000e-09 8.600000000000e-01 1.389532000000e-09 8.600000000000e-01 1.390483000000e-09 8.600000000000e-01 1.393528000000e-09 8.600000000000e-01 1.396267000000e-09 8.600000000000e-01 1.399530000000e-09 8.600000000000e-01 1.403009000000e-09 8.600000000000e-01 1.406745000000e-09 8.600000000000e-01 1.410579000000e-09 8.600000000000e-01 1.413057000000e-09 8.600000000000e-01 1.415535000000e-09 8.600000000000e-01 1.418933000000e-09 8.600000000000e-01 1.419781000000e-09 8.600000000000e-01 1.420563000000e-09 8.600000000000e-01 1.423064000000e-09 8.600000000000e-01 1.426220000000e-09 8.600000000000e-01 1.429627000000e-09 8.600000000000e-01 1.432942000000e-09 8.600000000000e-01 1.436511000000e-09 8.600000000000e-01 1.439973000000e-09 8.600000000000e-01 1.444113000000e-09 8.600000000000e-01 1.447667000000e-09 8.600000000000e-01 1.448597000000e-09 8.600000000000e-01 1.449278000000e-09 8.600000000000e-01 1.451458000000e-09 8.600000000000e-01 1.454984000000e-09 8.600000000000e-01 1.458241000000e-09 8.600000000000e-01 1.461761000000e-09 8.600000000000e-01 1.465886000000e-09 8.600000000000e-01 1.469389000000e-09 8.600000000000e-01 1.472794000000e-09 8.600000000000e-01 1.475276000000e-09 8.600000000000e-01 1.477758000000e-09 8.600000000000e-01 1.479095000000e-09 8.600000000000e-01 1.479882000000e-09 8.600000000000e-01 1.482402000000e-09 8.600000000000e-01 1.485321000000e-09 8.600000000000e-01 1.488790000000e-09 8.600000000000e-01 1.492381000000e-09 8.600000000000e-01 1.496661000000e-09 8.600000000000e-01 1.500576000000e-09 8.600000000000e-01 1.504103000000e-09 8.600000000000e-01 1.508121000000e-09 8.600000000000e-01 1.509046000000e-09 8.600000000000e-01 1.509764000000e-09 8.600000000000e-01 1.512062000000e-09 8.600000000000e-01 1.514727000000e-09 8.600000000000e-01 1.518391000000e-09 8.600000000000e-01 1.521668000000e-09 8.600000000000e-01 1.525243000000e-09 8.600000000000e-01 1.529365000000e-09 8.600000000000e-01 1.532875000000e-09 8.600000000000e-01 1.534025000000e-09 8.600000000000e-01 1.534117000000e-09 8.600000000000e-01 1.534180000000e-09 8.600000000000e-01 1.534382000000e-09 8.600000000000e-01 1.534737000000e-09 8.600000000000e-01 1.535025000000e-09 8.600000000000e-01 1.535086000000e-09 8.600000000000e-01 1.535120000000e-09 8.600000000000e-01 1.535227000000e-09 8.600000000000e-01 1.535516000000e-09 8.600000000000e-01 1.535770000000e-09 8.600000000000e-01 1.536253000000e-09 8.600000000000e-01 1.537797000000e-09 8.600000000000e-01 1.540037000000e-09 8.600000000000e-01 1.542991000000e-09 8.600000000000e-01 1.546340000000e-09 8.600000000000e-01 1.549563000000e-09 8.600000000000e-01 1.553023000000e-09 8.600000000000e-01 1.556674000000e-09 8.600000000000e-01 1.561332000000e-09 8.600000000000e-01 1.564959000000e-09 8.600000000000e-01 1.568637000000e-09 8.600000000000e-01 1.572862000000e-09 8.600000000000e-01 1.576410000000e-09 8.600000000000e-01 1.580380000000e-09 8.600000000000e-01 1.584817000000e-09 8.600000000000e-01 1.588226000000e-09 8.600000000000e-01 1.592181000000e-09 8.600000000000e-01 1.595925000000e-09 8.600000000000e-01 1.599741000000e-09 8.600000000000e-01 1.604581000000e-09 8.600000000000e-01 1.606342000000e-09 8.600000000000e-01 1.608103000000e-09 8.600000000000e-01 1.611836000000e-09 8.600000000000e-01 1.616035000000e-09 8.600000000000e-01 1.619218000000e-09 8.600000000000e-01 1.623182000000e-09 8.600000000000e-01 1.626358000000e-09 8.600000000000e-01 1.629985000000e-09 8.600000000000e-01 1.634074000000e-09 8.600000000000e-01 1.638238000000e-09 8.600000000000e-01 1.643068000000e-09 8.600000000000e-01 1.648476000000e-09 8.600000000000e-01 1.653917000000e-09 8.600000000000e-01 1.658595000000e-09 8.600000000000e-01 1.665047000000e-09 8.600000000000e-01 1.668427000000e-09 8.600000000000e-01 1.674362000000e-09 8.600000000000e-01 1.678501000000e-09 8.600000000000e-01 1.684581000000e-09 8.600000000000e-01 1.686093000000e-09 8.600000000000e-01 1.687486000000e-09 8.600000000000e-01 1.691945000000e-09 8.600000000000e-01 1.695547000000e-09 8.600000000000e-01 1.700342000000e-09 8.600000000000e-01 1.704014000000e-09 8.600000000000e-01 1.707642000000e-09 8.600000000000e-01 1.712914000000e-09 8.600000000000e-01 1.717024000000e-09 8.600000000000e-01 1.722796000000e-09 8.600000000000e-01 1.724262000000e-09 8.600000000000e-01 1.725743000000e-09 8.600000000000e-01 1.730482000000e-09 8.600000000000e-01 1.734128000000e-09 8.600000000000e-01 1.739613000000e-09 8.600000000000e-01 1.743241000000e-09 8.600000000000e-01 1.746998000000e-09 8.600000000000e-01 1.752400000000e-09 8.600000000000e-01 1.756586000000e-09 8.600000000000e-01 1.762468000000e-09 8.600000000000e-01 1.764025000000e-09 8.600000000000e-01 1.765380000000e-09 8.600000000000e-01 1.769719000000e-09 8.600000000000e-01 1.773264000000e-09 8.600000000000e-01 1.778028000000e-09 8.600000000000e-01 1.781718000000e-09 8.600000000000e-01 1.785310000000e-09 8.600000000000e-01 1.790811000000e-09 8.600000000000e-01 1.794844000000e-09 8.600000000000e-01 1.800637000000e-09 8.600000000000e-01 1.802097000000e-09 8.600000000000e-01 1.803580000000e-09 8.600000000000e-01 1.808326000000e-09 8.600000000000e-01 1.811970000000e-09 8.600000000000e-01 1.817496000000e-09 8.600000000000e-01 1.821120000000e-09 8.600000000000e-01 1.824884000000e-09 8.600000000000e-01 1.830308000000e-09 8.600000000000e-01 1.834495000000e-09 8.600000000000e-01 1.840377000000e-09 8.600000000000e-01 1.841939000000e-09 8.600000000000e-01 1.843284000000e-09 8.600000000000e-01 1.847586000000e-09 8.600000000000e-01 1.851115000000e-09 8.600000000000e-01 1.855851000000e-09 8.600000000000e-01 1.859543000000e-09 8.600000000000e-01 1.863125000000e-09 8.600000000000e-01 1.868621000000e-09 8.600000000000e-01 1.872640000000e-09 8.600000000000e-01 1.878406000000e-09 8.600000000000e-01 1.879857000000e-09 8.600000000000e-01 1.881342000000e-09 8.600000000000e-01 1.886097000000e-09 8.600000000000e-01 1.889729000000e-09 8.600000000000e-01 1.895406000000e-09 8.600000000000e-01 1.899019000000e-09 8.600000000000e-01 1.902802000000e-09 8.600000000000e-01 1.908327000000e-09 8.600000000000e-01 1.912510000000e-09 8.600000000000e-01 1.918396000000e-09 8.600000000000e-01 1.923452000000e-09 8.600000000000e-01 1.928319000000e-09 8.600000000000e-01 1.933832000000e-09 8.600000000000e-01 1.937865000000e-09 8.600000000000e-01 1.941516000000e-09 8.600000000000e-01 1.947123000000e-09 8.600000000000e-01 1.951206000000e-09 8.600000000000e-01 1.957151000000e-09 8.600000000000e-01 1.962202000000e-09 8.600000000000e-01 1.967100000000e-09 8.600000000000e-01 1.968013000000e-09 8.600000000000e-01 1.969099000000e-09 8.600000000000e-01 1.972453000000e-09 8.600000000000e-01 1.975701000000e-09 8.600000000000e-01 1.979195000000e-09 8.600000000000e-01 1.983866000000e-09 8.600000000000e-01 1.987814000000e-09 8.600000000000e-01 1.993099000000e-09 8.600000000000e-01 1.998488000000e-09 8.600000000000e-01 2.003935000000e-09 8.600000000000e-01 2.004866000000e-09 8.600000000000e-01 2.005730000000e-09 8.600000000000e-01 2.008495000000e-09 8.600000000000e-01 2.013208000000e-09 8.600000000000e-01 2.016501000000e-09 8.600000000000e-01 2.021215000000e-09 8.600000000000e-01 2.025252000000e-09 8.600000000000e-01 2.030301000000e-09 8.600000000000e-01 2.035760000000e-09 8.600000000000e-01 2.040977000000e-09 8.600000000000e-01 2.042009000000e-09 8.600000000000e-01 2.042812000000e-09 8.600000000000e-01 2.045379000000e-09 8.600000000000e-01 2.049639000000e-09 8.600000000000e-01 2.053254000000e-09 8.600000000000e-01 2.056728000000e-09 8.600000000000e-01 2.062152000000e-09 8.600000000000e-01 2.066039000000e-09 8.600000000000e-01 2.071558000000e-09 8.600000000000e-01 2.076872000000e-09 8.600000000000e-01 2.078300000000e-09 8.600000000000e-01 2.079144000000e-09 8.600000000000e-01 2.081843000000e-09 8.600000000000e-01 2.085459000000e-09 8.600000000000e-01 2.089564000000e-09 8.600000000000e-01 2.093109000000e-09 8.600000000000e-01 2.096789000000e-09 8.600000000000e-01 2.101106000000e-09 8.600000000000e-01 2.105378000000e-09 8.600000000000e-01 2.110838000000e-09 8.600000000000e-01 2.112251000000e-09 8.600000000000e-01 2.113753000000e-09 8.600000000000e-01 2.118558000000e-09 8.600000000000e-01 2.122133000000e-09 8.600000000000e-01 2.129360000000e-09 8.600000000000e-01 2.132821000000e-09 8.600000000000e-01 2.136929000000e-09 8.600000000000e-01 2.139763000000e-09 8.600000000000e-01 2.142597000000e-09 8.600000000000e-01 2.147012000000e-09 8.600000000000e-01 2.152765000000e-09 8.600000000000e-01 2.154377000000e-09 8.600000000000e-01 2.155442000000e-09 8.600000000000e-01 2.158852000000e-09 8.600000000000e-01 2.162621000000e-09 8.600000000000e-01 2.166944000000e-09 8.600000000000e-01 2.170618000000e-09 8.600000000000e-01 2.174167000000e-09 8.600000000000e-01 2.179170000000e-09 8.600000000000e-01 2.183292000000e-09 8.600000000000e-01 2.188867000000e-09 8.600000000000e-01 2.190278000000e-09 8.600000000000e-01 2.191779000000e-09 8.600000000000e-01 2.196584000000e-09 8.600000000000e-01 2.200169000000e-09 8.600000000000e-01 2.207050000000e-09 8.600000000000e-01 2.210543000000e-09 8.600000000000e-01 2.214570000000e-09 8.600000000000e-01 2.217383000000e-09 8.600000000000e-01 2.220196000000e-09 8.600000000000e-01 2.224548000000e-09 8.600000000000e-01 2.230327000000e-09 8.600000000000e-01 2.231668000000e-09 8.600000000000e-01 2.232487000000e-09 8.600000000000e-01 2.235108000000e-09 8.600000000000e-01 2.238430000000e-09 8.600000000000e-01 2.242101000000e-09 8.600000000000e-01 2.245250000000e-09 8.600000000000e-01 2.248623000000e-09 8.600000000000e-01 2.252399000000e-09 8.600000000000e-01 2.256336000000e-09 8.600000000000e-01 2.261919000000e-09 8.600000000000e-01 2.264384000000e-09 8.600000000000e-01 2.265883000000e-09 8.600000000000e-01 2.270679000000e-09 8.600000000000e-01 2.277378000000e-09 8.600000000000e-01 2.283984000000e-09 8.600000000000e-01 2.291963000000e-09 8.600000000000e-01 2.303337000000e-09 8.600000000000e-01 2.323042000000e-09 8.600000000000e-01 2.352076000000e-09 8.600000000000e-01 2.407975000000e-09 8.600000000000e-01 2.543499000000e-09 8.600000000000e-01 2.778736000000e-09 8.600000000000e-01 3.128736000000e-09 8.600000000000e-01 3.478736000000e-09 8.600000000000e-01 3.828736000000e-09 8.600000000000e-01 4.076000000000e-09 8.600000000000e-01 4.076500000000e-09 9.050000000000e-01 4.077000000000e-09 9.500000000000e-01 4.077306000000e-09 9.500000000000e-01 4.077515000000e-09 9.500000000000e-01 4.078112000000e-09 9.500000000000e-01 4.079900000000e-09 9.500000000000e-01 4.082540000000e-09 9.500000000000e-01 4.086501000000e-09 9.500000000000e-01 4.092049000000e-09 9.500000000000e-01 4.100074000000e-09 9.500000000000e-01 4.112222000000e-09 9.500000000000e-01 4.128358000000e-09 9.500000000000e-01 4.151784000000e-09 9.500000000000e-01 4.181738000000e-09 9.500000000000e-01 4.223091000000e-09 9.500000000000e-01 4.287381000000e-09 9.500000000000e-01 4.412795000000e-09 9.500000000000e-01 4.639879000000e-09 9.500000000000e-01 4.989879000000e-09 9.500000000000e-01 5.339879000000e-09 9.500000000000e-01 5.689879000000e-09 9.500000000000e-01 6.039879000000e-09 9.500000000000e-01 6.389879000000e-09 9.500000000000e-01 6.739879000000e-09 9.500000000000e-01 7.000000000000e-09 9.500000000000e-01)
V_VDD_SAFE vdd_safe 0 DC 1.100000000000e+00
V_VSS_SAFE vss_safe 0 DC 0
* The bridge's D2A high level is normalized by a zero-delay ideal source.
* This source has no slew, delay, hysteresis, pulse filter, or X-region.
V_XOR_00 xor_00 0 PWL(0.000000000000e+00 6.995221000000e-06 1.000000000000e-12 6.997985000000e-06 2.000000000000e-12 7.000502000000e-06 5.200000000000e-12 7.006871000000e-06 1.544000000000e-11 7.014253000000e-06 4.820800000000e-11 7.014547000000e-06 1.530656000000e-10 7.014629000000e-06 4.886099000000e-10 7.014537000000e-06 8.386099000000e-10 7.014631000000e-06 9.995000000000e-10 7.014536000000e-06 9.996500000000e-10 2.858665000000e-05 1.000130000000e-09 7.349373000000e-05 1.000271000000e-09 8.158428000000e-05 1.000500000000e-09 6.955755000000e-05 1.000549000000e-09 5.704254000000e-05 1.000579000000e-09 4.735680000000e-05 1.000674000000e-09 1.050785000000e-05 1.000921000000e-09 -7.209172000000e-05 1.001177000000e-09 -1.336688000000e-04 1.001636000000e-09 -2.061063000000e-04 1.002995000000e-09 -2.722562000000e-04 1.004717000000e-09 -1.435160000000e-04 1.007157000000e-09 5.313174000000e-04 1.009530000000e-09 1.382083000000e-03 1.012064000000e-09 1.435679000000e-03 1.014479000000e-09 -1.109247000000e-03 1.016999000000e-09 -7.994260000000e-03 1.019780000000e-09 -1.906134000000e-02 1.023006000000e-09 -1.491865000000e-02 1.025715000000e-09 3.032633000000e-02 1.028767000000e-09 1.320797000000e-01 1.031545000000e-09 2.371959000000e-01 1.034548000000e-09 3.360410000000e-01 1.037295000000e-09 4.190738000000e-01 1.040188000000e-09 5.097229000000e-01 1.042931000000e-09 5.948506000000e-01 1.046095000000e-09 6.808399000000e-01 1.049020000000e-09 7.419246000000e-01 1.051920000000e-09 7.858249000000e-01 1.055268000000e-09 8.217921000000e-01 1.057963000000e-09 8.440967000000e-01 1.059420000000e-09 8.552046000000e-01 1.060877000000e-09 8.656424000000e-01 1.063981000000e-09 8.859507000000e-01 1.066813000000e-09 9.011680000000e-01 1.069715000000e-09 9.134560000000e-01 1.073141000000e-09 9.238782000000e-01 1.075000000000e-09 9.275180000000e-01 1.075500000000e-09 9.043748000000e-01 1.075834000000e-09 8.885134000000e-01 1.076000000000e-09 8.804678000000e-01 1.076266000000e-09 8.800432000000e-01 1.076419000000e-09 8.800234000000e-01 1.076822000000e-09 8.801470000000e-01 1.078112000000e-09 8.786970000000e-01 1.079915000000e-09 8.747624000000e-01 1.082834000000e-09 8.674077000000e-01 1.086452000000e-09 8.613026000000e-01 1.089863000000e-09 8.653090000000e-01 1.094093000000e-09 8.830197000000e-01 1.097558000000e-09 8.998363000000e-01 1.101264000000e-09 9.105026000000e-01 1.105520000000e-09 8.832641000000e-01 1.109056000000e-09 8.014341000000e-01 1.112992000000e-09 6.539000000000e-01 1.115807000000e-09 5.372753000000e-01 1.118621000000e-09 4.113541000000e-01 1.121942000000e-09 2.865158000000e-01 1.125724000000e-09 1.773495000000e-01 1.129501000000e-09 1.069818000000e-01 1.133249000000e-09 6.684457000000e-02 1.135809000000e-09 4.881240000000e-02 1.138369000000e-09 3.839165000000e-02 1.141791000000e-09 2.932250000000e-02 1.145734000000e-09 2.269896000000e-02 1.150017000000e-09 1.709682000000e-02 1.153865000000e-09 1.236681000000e-02 1.158361000000e-09 7.956539000000e-03 1.161824000000e-09 5.386938000000e-03 1.165535000000e-09 3.558995000000e-03 1.169527000000e-09 2.223349000000e-03 1.173109000000e-09 1.564632000000e-03 1.177056000000e-09 1.037791000000e-03 1.179535000000e-09 8.391666000000e-04 1.182013000000e-09 7.425321000000e-04 1.185429000000e-09 5.704795000000e-04 1.189651000000e-09 5.426076000000e-04 1.193349000000e-09 5.065445000000e-04 1.197208000000e-09 6.215021000000e-04 1.200595000000e-09 6.621450000000e-04 1.204042000000e-09 7.955674000000e-04 1.207661000000e-09 8.406187000000e-04 1.212044000000e-09 9.518202000000e-04 1.215603000000e-09 9.222011000000e-04 1.219624000000e-09 9.269550000000e-04 1.222280000000e-09 8.777238000000e-04 1.224935000000e-09 7.868354000000e-04 1.228316000000e-09 7.437498000000e-04 1.229186000000e-09 7.028355000000e-04 1.230042000000e-09 6.792297000000e-04 1.232779000000e-09 6.122629000000e-04 1.235670000000e-09 5.386427000000e-04 1.238863000000e-09 4.676264000000e-04 1.243639000000e-09 3.711312000000e-04 1.246999000000e-09 3.135875000000e-04 1.250850000000e-09 2.558110000000e-04 1.255187000000e-09 2.030860000000e-04 1.258822000000e-09 1.660080000000e-04 1.259631000000e-09 1.591931000000e-04 1.260438000000e-09 1.522972000000e-04 1.263021000000e-09 1.320715000000e-04 1.265957000000e-09 1.123041000000e-04 1.269137000000e-09 9.419636000000e-05 1.273131000000e-09 7.562315000000e-05 1.276658000000e-09 6.241649000000e-05 1.280195000000e-09 5.166079000000e-05 1.284359000000e-09 4.154248000000e-05 1.288216000000e-09 3.418404000000e-05 1.291735000000e-09 2.879189000000e-05 1.292574000000e-09 2.770389000000e-05 1.293423000000e-09 2.662604000000e-05 1.296139000000e-09 2.351750000000e-05 1.299136000000e-09 2.063099000000e-05 1.302736000000e-09 1.778684000000e-05 1.306959000000e-09 1.515267000000e-05 1.310392000000e-09 1.346235000000e-05 1.314112000000e-09 1.198948000000e-05 1.317424000000e-09 1.093227000000e-05 1.320972000000e-09 1.001454000000e-05 1.324632000000e-09 9.255186000000e-06 1.327145000000e-09 8.819130000000e-06 1.329658000000e-09 8.452582000000e-06 1.333049000000e-09 8.037032000000e-06 1.337028000000e-09 7.647964000000e-06 1.341293000000e-09 7.323571000000e-06 1.345153000000e-09 7.095722000000e-06 1.349994000000e-09 6.876048000000e-06 1.353616000000e-09 6.750261000000e-06 1.357116000000e-09 6.652142000000e-06 1.357983000000e-09 6.631661000000e-06 1.358962000000e-09 6.609153000000e-06 1.362092000000e-09 6.545388000000e-06 1.364885000000e-09 6.498029000000e-06 1.369987000000e-09 6.429614000000e-06 1.373500000000e-09 6.393749000000e-06 1.377230000000e-09 6.363242000000e-06 1.381288000000e-09 6.337110000000e-06 1.384815000000e-09 6.319152000000e-06 1.388662000000e-09 6.303538000000e-06 1.389532000000e-09 6.300576000000e-06 1.390483000000e-09 6.297432000000e-06 1.393528000000e-09 6.288497000000e-06 1.396267000000e-09 6.281776000000e-06 1.399530000000e-09 6.275107000000e-06 1.403009000000e-09 6.269321000000e-06 1.406745000000e-09 6.264343000000e-06 1.410579000000e-09 6.260295000000e-06 1.413057000000e-09 6.258118000000e-06 1.415535000000e-09 6.256286000000e-06 1.418933000000e-09 6.254172000000e-06 1.419781000000e-09 6.253723000000e-06 1.420563000000e-09 6.253319000000e-06 1.423064000000e-09 6.252148000000e-06 1.426220000000e-09 6.250903000000e-06 1.429627000000e-09 6.249803000000e-06 1.432942000000e-09 6.248934000000e-06 1.436511000000e-09 6.248176000000e-06 1.439973000000e-09 6.247583000000e-06 1.444113000000e-09 6.247022000000e-06 1.447667000000e-09 6.246643000000e-06 1.448597000000e-09 6.246558000000e-06 1.449278000000e-09 6.246498000000e-06 1.451458000000e-09 6.246321000000e-06 1.454984000000e-09 6.246081000000e-06 1.458241000000e-09 6.245901000000e-06 1.461761000000e-09 6.245742000000e-06 1.465886000000e-09 6.245596000000e-06 1.469389000000e-09 6.245496000000e-06 1.472794000000e-09 6.245419000000e-06 1.475276000000e-09 6.245372000000e-06 1.477758000000e-09 6.245332000000e-06 1.479095000000e-09 6.245313000000e-06 1.479882000000e-09 6.245302000000e-06 1.482402000000e-09 6.245272000000e-06 1.485321000000e-09 6.245241000000e-06 1.488790000000e-09 6.245212000000e-06 1.492381000000e-09 6.245187000000e-06 1.496661000000e-09 6.245165000000e-06 1.500576000000e-09 6.245146000000e-06 1.504103000000e-09 6.245136000000e-06 1.508121000000e-09 6.245125000000e-06 1.509046000000e-09 6.245123000000e-06 1.509764000000e-09 6.245121000000e-06 1.512062000000e-09 6.245117000000e-06 1.514727000000e-09 6.245114000000e-06 1.518391000000e-09 6.245106000000e-06 1.521668000000e-09 6.245103000000e-06 1.525243000000e-09 6.245100000000e-06 1.529365000000e-09 6.245097000000e-06 1.532875000000e-09 6.245095000000e-06 1.534025000000e-09 6.245094000000e-06 1.534117000000e-09 -1.329033000000e-03 1.534180000000e-09 -2.235251000000e-03 1.534382000000e-09 -4.846284000000e-03 1.534737000000e-09 -8.561371000000e-03 1.535025000000e-09 -1.069071000000e-02 1.535086000000e-09 -1.023047000000e-02 1.535120000000e-09 -9.970249000000e-03 1.535227000000e-09 -9.177308000000e-03 1.535516000000e-09 -7.269406000000e-03 1.535770000000e-09 -5.873349000000e-03 1.536253000000e-09 -3.761482000000e-03 1.537797000000e-09 2.266622000000e-04 1.540037000000e-09 2.428694000000e-03 1.542991000000e-09 2.672208000000e-03 1.546340000000e-09 1.529819000000e-03 1.549563000000e-09 5.585466000000e-04 1.553023000000e-09 -8.581737000000e-05 1.556674000000e-09 -3.335736000000e-04 1.561332000000e-09 -2.896460000000e-04 1.564959000000e-09 -1.783164000000e-04 1.568637000000e-09 -9.937216000000e-05 1.572862000000e-09 -4.707158000000e-05 1.576410000000e-09 -2.370419000000e-05 1.580380000000e-09 -7.840904000000e-06 1.584817000000e-09 -2.076363000000e-06 1.588226000000e-09 3.532660000000e-06 1.592181000000e-09 3.119223000000e-06 1.595925000000e-09 6.527176000000e-06 1.599741000000e-09 4.680733000000e-06 1.604581000000e-09 7.434625000000e-06 1.606342000000e-09 6.715771000000e-06 1.608103000000e-09 5.078985000000e-06 1.611836000000e-09 7.631657000000e-06 1.616035000000e-09 5.128000000000e-06 1.619218000000e-09 7.702608000000e-06 1.623182000000e-09 5.094823000000e-06 1.626358000000e-09 7.769823000000e-06 1.629985000000e-09 5.033772000000e-06 1.634074000000e-09 7.779065000000e-06 1.638238000000e-09 4.979623000000e-06 1.643068000000e-09 7.773593000000e-06 1.648476000000e-09 4.930013000000e-06 1.653917000000e-09 7.766133000000e-06 1.658595000000e-09 4.896561000000e-06 1.665047000000e-09 7.773015000000e-06 1.668427000000e-09 4.872770000000e-06 1.674362000000e-09 7.793933000000e-06 1.678501000000e-09 4.851799000000e-06 1.684581000000e-09 7.802456000000e-06 1.686093000000e-09 6.301580000000e-06 1.687486000000e-09 6.319478000000e-06 1.691945000000e-09 6.286081000000e-06 1.695547000000e-09 6.288557000000e-06 1.700342000000e-09 6.271568000000e-06 1.704014000000e-09 6.279542000000e-06 1.707642000000e-09 6.268417000000e-06 1.712914000000e-09 6.276627000000e-06 1.717024000000e-09 6.267169000000e-06 1.722796000000e-09 6.275328000000e-06 1.724262000000e-09 6.271167000000e-06 1.725743000000e-09 6.270778000000e-06 1.730482000000e-09 6.270798000000e-06 1.734128000000e-09 6.270455000000e-06 1.739613000000e-09 6.270507000000e-06 1.743241000000e-09 6.270195000000e-06 1.746998000000e-09 6.270324000000e-06 1.752400000000e-09 6.269989000000e-06 1.756586000000e-09 6.270119000000e-06 1.762468000000e-09 6.269824000000e-06 1.764025000000e-09 6.269926000000e-06 1.765380000000e-09 6.269874000000e-06 1.769719000000e-09 6.269815000000e-06 1.773264000000e-09 6.269787000000e-06 1.778028000000e-09 6.269737000000e-06 1.781718000000e-09 6.269703000000e-06 1.785310000000e-09 6.269666000000e-06 1.790811000000e-09 6.269621000000e-06 1.794844000000e-09 6.269591000000e-06 1.800637000000e-09 6.269562000000e-06 1.802097000000e-09 6.269564000000e-06 1.803580000000e-09 6.269528000000e-06 1.808326000000e-09 6.269495000000e-06 1.811970000000e-09 6.269488000000e-06 1.817496000000e-09 6.269461000000e-06 1.821120000000e-09 6.269436000000e-06 1.824884000000e-09 6.269426000000e-06 1.830308000000e-09 6.269412000000e-06 1.834495000000e-09 6.269396000000e-06 1.840377000000e-09 6.269380000000e-06 1.841939000000e-09 6.269386000000e-06 1.843284000000e-09 6.269363000000e-06 1.847586000000e-09 6.269346000000e-06 1.851115000000e-09 6.269344000000e-06 1.855851000000e-09 6.269333000000e-06 1.859543000000e-09 6.269324000000e-06 1.863125000000e-09 6.269316000000e-06 1.868621000000e-09 6.269303000000e-06 1.872640000000e-09 6.269296000000e-06 1.878406000000e-09 6.269285000000e-06 1.879857000000e-09 6.269291000000e-06 1.881342000000e-09 6.269277000000e-06 1.886097000000e-09 6.269268000000e-06 1.889729000000e-09 6.269267000000e-06 1.895406000000e-09 6.269259000000e-06 1.899019000000e-09 6.269267000000e-06 1.902802000000e-09 6.269246000000e-06 1.908327000000e-09 6.269240000000e-06 1.912510000000e-09 6.269237000000e-06 1.918396000000e-09 6.269230000000e-06 1.923452000000e-09 6.269227000000e-06 1.928319000000e-09 6.269221000000e-06 1.933832000000e-09 6.269217000000e-06 1.937865000000e-09 6.269213000000e-06 1.941516000000e-09 6.269211000000e-06 1.947123000000e-09 6.269205000000e-06 1.951206000000e-09 6.269204000000e-06 1.957151000000e-09 6.269198000000e-06 1.962202000000e-09 6.269196000000e-06 1.967100000000e-09 6.269192000000e-06 1.968013000000e-09 6.269197000000e-06 1.969099000000e-09 6.269188000000e-06 1.972453000000e-09 6.269189000000e-06 1.975701000000e-09 6.269188000000e-06 1.979195000000e-09 6.269186000000e-06 1.983866000000e-09 6.269184000000e-06 1.987814000000e-09 6.269182000000e-06 1.993099000000e-09 6.269187000000e-06 1.998488000000e-09 6.269167000000e-06 2.003935000000e-09 6.269177000000e-06 2.004866000000e-09 6.269181000000e-06 2.005730000000e-09 6.269174000000e-06 2.008495000000e-09 6.269174000000e-06 2.013208000000e-09 6.269171000000e-06 2.016501000000e-09 6.269170000000e-06 2.021215000000e-09 6.269168000000e-06 2.025252000000e-09 6.269167000000e-06 2.030301000000e-09 6.269165000000e-06 2.035760000000e-09 6.269164000000e-06 2.040977000000e-09 6.269162000000e-06 2.042009000000e-09 6.269166000000e-06 2.042812000000e-09 6.269159000000e-06 2.045379000000e-09 6.269160000000e-06 2.049639000000e-09 6.269159000000e-06 2.053254000000e-09 6.269159000000e-06 2.056728000000e-09 6.269158000000e-06 2.062152000000e-09 6.269157000000e-06 2.066039000000e-09 6.269156000000e-06 2.071558000000e-09 6.269154000000e-06 2.076872000000e-09 6.269153000000e-06 2.078300000000e-09 6.269158000000e-06 2.079144000000e-09 6.269148000000e-06 2.081843000000e-09 6.269151000000e-06 2.085459000000e-09 6.269152000000e-06 2.089564000000e-09 6.269151000000e-06 2.093109000000e-09 6.269150000000e-06 2.096789000000e-09 6.269150000000e-06 2.101106000000e-09 6.269149000000e-06 2.105378000000e-09 6.269148000000e-06 2.110838000000e-09 6.269147000000e-06 2.112251000000e-09 6.269151000000e-06 2.113753000000e-09 6.269142000000e-06 2.118558000000e-09 6.269147000000e-06 2.122133000000e-09 6.269146000000e-06 2.129360000000e-09 6.269145000000e-06 2.132821000000e-09 6.269144000000e-06 2.136929000000e-09 6.269143000000e-06 2.139763000000e-09 6.269143000000e-06 2.142597000000e-09 6.269143000000e-06 2.147012000000e-09 6.269142000000e-06 2.152765000000e-09 6.269141000000e-06 2.154377000000e-09 6.269145000000e-06 2.155442000000e-09 6.269136000000e-06 2.158852000000e-09 6.269141000000e-06 2.162621000000e-09 6.269140000000e-06 2.166944000000e-09 6.269151000000e-06 2.170618000000e-09 6.269136000000e-06 2.174167000000e-09 6.269136000000e-06 2.179170000000e-09 6.269138000000e-06 2.183292000000e-09 6.269137000000e-06 2.188867000000e-09 6.269138000000e-06 2.190278000000e-09 6.269141000000e-06 2.191779000000e-09 6.269134000000e-06 2.196584000000e-09 6.269138000000e-06 2.200169000000e-09 6.269137000000e-06 2.207050000000e-09 6.269136000000e-06 2.210543000000e-09 6.269136000000e-06 2.214570000000e-09 6.269136000000e-06 2.217383000000e-09 6.269135000000e-06 2.220196000000e-09 6.269135000000e-06 2.224548000000e-09 6.269135000000e-06 2.230327000000e-09 6.269135000000e-06 2.231668000000e-09 6.269137000000e-06 2.232487000000e-09 6.269132000000e-06 2.235108000000e-09 6.269134000000e-06 2.238430000000e-09 6.269134000000e-06 2.242101000000e-09 6.269134000000e-06 2.245250000000e-09 6.269134000000e-06 2.248623000000e-09 6.269133000000e-06 2.252399000000e-09 6.269133000000e-06 2.256336000000e-09 6.269133000000e-06 2.261919000000e-09 6.269133000000e-06 2.264384000000e-09 6.269134000000e-06 2.265883000000e-09 6.269133000000e-06 2.270679000000e-09 6.269128000000e-06 2.277378000000e-09 6.269134000000e-06 2.283984000000e-09 6.269131000000e-06 2.291963000000e-09 6.269131000000e-06 2.303337000000e-09 6.269130000000e-06 2.323042000000e-09 6.269130000000e-06 2.352076000000e-09 6.269129000000e-06 2.407975000000e-09 6.269127000000e-06 2.543499000000e-09 6.269125000000e-06 2.778736000000e-09 6.269122000000e-06 3.128736000000e-09 6.269121000000e-06 3.478736000000e-09 6.269121000000e-06 3.828736000000e-09 6.269121000000e-06 4.076000000000e-09 6.269121000000e-06 4.076500000000e-09 2.037910000000e-02 4.077000000000e-09 4.006933000000e-02 4.077306000000e-09 3.905048000000e-02 4.077515000000e-09 3.825565000000e-02 4.078112000000e-09 3.572360000000e-02 4.079900000000e-09 2.852135000000e-02 4.082540000000e-09 1.956224000000e-02 4.086501000000e-09 1.040131000000e-02 4.092049000000e-09 3.780476000000e-03 4.100074000000e-09 6.724139000000e-04 4.112222000000e-09 -3.217162000000e-05 4.128358000000e-09 2.222341000000e-05 4.151784000000e-09 -4.375323000000e-06 4.181738000000e-09 1.638179000000e-05 4.223091000000e-09 -1.203307000000e-06 4.287381000000e-09 1.498238000000e-05 4.412795000000e-09 -8.369013000000e-07 4.639879000000e-09 1.496321000000e-05 4.989879000000e-09 -1.256194000000e-06 5.339879000000e-09 1.531351000000e-05 5.689879000000e-09 -1.552301000000e-06 6.039879000000e-09 1.559808000000e-05 6.389879000000e-09 -1.850774000000e-06 6.739879000000e-09 1.584589000000e-05 7.000000000000e-09 -2.138225000000e-06)
V_XOR_01 xor_01 0 PWL(0.000000000000e+00 6.995221000000e-06 1.000000000000e-12 6.997984000000e-06 2.000000000000e-12 7.000502000000e-06 5.200000000000e-12 7.006871000000e-06 1.544000000000e-11 7.014253000000e-06 4.820800000000e-11 7.014547000000e-06 1.530656000000e-10 7.014629000000e-06 4.886099000000e-10 7.014537000000e-06 8.386099000000e-10 7.014631000000e-06 9.995000000000e-10 7.014537000000e-06 9.996500000000e-10 7.699354000000e-06 1.000130000000e-09 8.138379000000e-06 1.000271000000e-09 8.191711000000e-06 1.000500000000e-09 7.304123000000e-06 1.000549000000e-09 7.272149000000e-06 1.000579000000e-09 6.942655000000e-06 1.000674000000e-09 5.731334000000e-06 1.000921000000e-09 3.428016000000e-06 1.001177000000e-09 2.404960000000e-06 1.001636000000e-09 2.579384000000e-06 1.002995000000e-09 5.279296000000e-06 1.004717000000e-09 1.022474000000e-05 1.007157000000e-09 1.576819000000e-05 1.009530000000e-09 1.381595000000e-05 1.012064000000e-09 -1.833008000000e-06 1.014479000000e-09 -3.395388000000e-05 1.016999000000e-09 -7.797006000000e-05 1.019780000000e-09 -8.850851000000e-05 1.023006000000e-09 2.697464000000e-04 1.025715000000e-09 1.014607000000e-03 1.028767000000e-09 1.336224000000e-03 1.031545000000e-09 -1.322257000000e-03 1.034548000000e-09 -9.827422000000e-03 1.037295000000e-09 -2.059739000000e-02 1.040188000000e-09 -1.502264000000e-02 1.042931000000e-09 3.405136000000e-02 1.046095000000e-09 1.422802000000e-01 1.049020000000e-09 2.518145000000e-01 1.051920000000e-09 3.455985000000e-01 1.055268000000e-09 4.474849000000e-01 1.057963000000e-09 5.324326000000e-01 1.059420000000e-09 5.770496000000e-01 1.060877000000e-09 6.207371000000e-01 1.063981000000e-09 7.001071000000e-01 1.066813000000e-09 7.544745000000e-01 1.069715000000e-09 7.948880000000e-01 1.073141000000e-09 8.289787000000e-01 1.075000000000e-09 8.438801000000e-01 1.075500000000e-09 8.244630000000e-01 1.075834000000e-09 8.110087000000e-01 1.076000000000e-09 8.041328000000e-01 1.076266000000e-09 8.053322000000e-01 1.076419000000e-09 8.061990000000e-01 1.076822000000e-09 8.087041000000e-01 1.078112000000e-09 8.150466000000e-01 1.079915000000e-09 8.214687000000e-01 1.082834000000e-09 8.292173000000e-01 1.086452000000e-09 8.367077000000e-01 1.089863000000e-09 8.421604000000e-01 1.094093000000e-09 8.467567000000e-01 1.097558000000e-09 8.491181000000e-01 1.101264000000e-09 8.510498000000e-01 1.105520000000e-09 8.526574000000e-01 1.109056000000e-09 8.534161000000e-01 1.112992000000e-09 8.536987000000e-01 1.115807000000e-09 8.535454000000e-01 1.118621000000e-09 8.530959000000e-01 1.121942000000e-09 8.520890000000e-01 1.125724000000e-09 8.537771000000e-01 1.129501000000e-09 8.634582000000e-01 1.133249000000e-09 8.806842000000e-01 1.135809000000e-09 8.922551000000e-01 1.138369000000e-09 9.036693000000e-01 1.141791000000e-09 9.047928000000e-01 1.145734000000e-09 8.569736000000e-01 1.150017000000e-09 7.265003000000e-01 1.153865000000e-09 5.641863000000e-01 1.158361000000e-09 3.731661000000e-01 1.161824000000e-09 2.520125000000e-01 1.165535000000e-09 1.550898000000e-01 1.169527000000e-09 9.140147000000e-02 1.173109000000e-09 5.912821000000e-02 1.177056000000e-09 3.911373000000e-02 1.179535000000e-09 3.109282000000e-02 1.182013000000e-09 2.657979000000e-02 1.185429000000e-09 2.160780000000e-02 1.189651000000e-09 1.628276000000e-02 1.193349000000e-09 1.189459000000e-02 1.197208000000e-09 8.152048000000e-03 1.200595000000e-09 5.616338000000e-03 1.204042000000e-09 3.812532000000e-03 1.207661000000e-09 2.504504000000e-03 1.212044000000e-09 1.583704000000e-03 1.215603000000e-09 1.105525000000e-03 1.219624000000e-09 8.160051000000e-04 1.222280000000e-09 6.734389000000e-04 1.224935000000e-09 5.695438000000e-04 1.228316000000e-09 5.351411000000e-04 1.229186000000e-09 5.168757000000e-04 1.230042000000e-09 5.154060000000e-04 1.232779000000e-09 5.324570000000e-04 1.235670000000e-09 5.849965000000e-04 1.238863000000e-09 6.618046000000e-04 1.243639000000e-09 7.847823000000e-04 1.246999000000e-09 8.653777000000e-04 1.250850000000e-09 9.271659000000e-04 1.255187000000e-09 9.411729000000e-04 1.258822000000e-09 9.065209000000e-04 1.259631000000e-09 8.932967000000e-04 1.260438000000e-09 8.793402000000e-04 1.263021000000e-09 8.278448000000e-04 1.265957000000e-09 7.601625000000e-04 1.269137000000e-09 6.814398000000e-04 1.273131000000e-09 5.822969000000e-04 1.276658000000e-09 4.991998000000e-04 1.280195000000e-09 4.230172000000e-04 1.284359000000e-09 3.442752000000e-04 1.288216000000e-09 2.821215000000e-04 1.291735000000e-09 2.340529000000e-04 1.292574000000e-09 2.239509000000e-04 1.293423000000e-09 2.139391000000e-04 1.296139000000e-09 1.845965000000e-04 1.299136000000e-09 1.566418000000e-04 1.302736000000e-09 1.284057000000e-04 1.306959000000e-09 1.016305000000e-04 1.310392000000e-09 8.410620000000e-05 1.314112000000e-09 6.861398000000e-05 1.317424000000e-09 5.737786000000e-05 1.320972000000e-09 4.753393000000e-05 1.324632000000e-09 3.932661000000e-05 1.327145000000e-09 3.459136000000e-05 1.329658000000e-09 3.058923000000e-05 1.333049000000e-09 2.604234000000e-05 1.337028000000e-09 2.177125000000e-05 1.341293000000e-09 1.820742000000e-05 1.345153000000e-09 1.569220000000e-05 1.349994000000e-09 1.326229000000e-05 1.353616000000e-09 1.186567000000e-05 1.357116000000e-09 1.078128000000e-05 1.357983000000e-09 1.055305000000e-05 1.358962000000e-09 1.030329000000e-05 1.362092000000e-09 9.595821000000e-06 1.364885000000e-09 9.069837000000e-06 1.369987000000e-09 8.309360000000e-06 1.373500000000e-09 7.910368000000e-06 1.377230000000e-09 7.570921000000e-06 1.381288000000e-09 7.279980000000e-06 1.384815000000e-09 7.080078000000e-06 1.388662000000e-09 6.906147000000e-06 1.389532000000e-09 6.873183000000e-06 1.390483000000e-09 6.838161000000e-06 1.393528000000e-09 6.738641000000e-06 1.396267000000e-09 6.663958000000e-06 1.399530000000e-09 6.589223000000e-06 1.403009000000e-09 6.524184000000e-06 1.406745000000e-09 6.468932000000e-06 1.410579000000e-09 6.423939000000e-06 1.413057000000e-09 6.399731000000e-06 1.415535000000e-09 6.379354000000e-06 1.418933000000e-09 6.355898000000e-06 1.419781000000e-09 6.350897000000e-06 1.420563000000e-09 6.346407000000e-06 1.423064000000e-09 6.333382000000e-06 1.426220000000e-09 6.319541000000e-06 1.429627000000e-09 6.307325000000e-06 1.432942000000e-09 6.297660000000e-06 1.436511000000e-09 6.289232000000e-06 1.439973000000e-09 6.282650000000e-06 1.444113000000e-09 6.276408000000e-06 1.447667000000e-09 6.272189000000e-06 1.448597000000e-09 6.271258000000e-06 1.449278000000e-09 6.270590000000e-06 1.451458000000e-09 6.268628000000e-06 1.454984000000e-09 6.265956000000e-06 1.458241000000e-09 6.263954000000e-06 1.461761000000e-09 6.262197000000e-06 1.465886000000e-09 6.260565000000e-06 1.469389000000e-09 6.259474000000e-06 1.472794000000e-09 6.258613000000e-06 1.475276000000e-09 6.258085000000e-06 1.477758000000e-09 6.257640000000e-06 1.479095000000e-09 6.257435000000e-06 1.479882000000e-09 6.257317000000e-06 1.482402000000e-09 6.256974000000e-06 1.485321000000e-09 6.256638000000e-06 1.488790000000e-09 6.256310000000e-06 1.492381000000e-09 6.256036000000e-06 1.496661000000e-09 6.255780000000e-06 1.500576000000e-09 6.255596000000e-06 1.504103000000e-09 6.255467000000e-06 1.508121000000e-09 6.255349000000e-06 1.509046000000e-09 6.255326000000e-06 1.509764000000e-09 6.255309000000e-06 1.512062000000e-09 6.255259000000e-06 1.514727000000e-09 6.255209000000e-06 1.518391000000e-09 6.255153000000e-06 1.521668000000e-09 6.255111000000e-06 1.525243000000e-09 6.255075000000e-06 1.529365000000e-09 6.255042000000e-06 1.532875000000e-09 6.255020000000e-06 1.534025000000e-09 6.255014000000e-06 1.534117000000e-09 -1.334349000000e-03 1.534180000000e-09 -2.241532000000e-03 1.534382000000e-09 -4.853098000000e-03 1.534737000000e-09 -8.568950000000e-03 1.535025000000e-09 -1.069726000000e-02 1.535086000000e-09 -1.023654000000e-02 1.535120000000e-09 -9.975929000000e-03 1.535227000000e-09 -9.181523000000e-03 1.535516000000e-09 -7.270644000000e-03 1.535770000000e-09 -5.872662000000e-03 1.536253000000e-09 -3.759017000000e-03 1.537797000000e-09 2.290745000000e-04 1.540037000000e-09 2.428558000000e-03 1.542991000000e-09 2.670871000000e-03 1.546340000000e-09 1.529423000000e-03 1.549563000000e-09 5.588163000000e-04 1.553023000000e-09 -8.553137000000e-05 1.556674000000e-09 -3.335172000000e-04 1.561332000000e-09 -2.896582000000e-04 1.564959000000e-09 -1.784164000000e-04 1.568637000000e-09 -9.940774000000e-05 1.572862000000e-09 -4.712877000000e-05 1.576410000000e-09 -2.368968000000e-05 1.580380000000e-09 -7.870058000000e-06 1.584817000000e-09 -2.047678000000e-06 1.588226000000e-09 3.477211000000e-06 1.592181000000e-09 3.167622000000e-06 1.595925000000e-09 6.504029000000e-06 1.599741000000e-09 4.713992000000e-06 1.604581000000e-09 7.408789000000e-06 1.606342000000e-09 6.707261000000e-06 1.608103000000e-09 5.108512000000e-06 1.611836000000e-09 7.604173000000e-06 1.616035000000e-09 5.155793000000e-06 1.619218000000e-09 7.675372000000e-06 1.623182000000e-09 5.121838000000e-06 1.626358000000e-09 7.709890000000e-06 1.629985000000e-09 5.076950000000e-06 1.634074000000e-09 7.759704000000e-06 1.638238000000e-09 5.008782000000e-06 1.643068000000e-09 7.749832000000e-06 1.648476000000e-09 4.955684000000e-06 1.653917000000e-09 7.741408000000e-06 1.658595000000e-09 4.921732000000e-06 1.665047000000e-09 7.748060000000e-06 1.668427000000e-09 4.897603000000e-06 1.674362000000e-09 7.768994000000e-06 1.678501000000e-09 4.876203000000e-06 1.684581000000e-09 7.777884000000e-06 1.686093000000e-09 6.300699000000e-06 1.687486000000e-09 6.320427000000e-06 1.691945000000e-09 6.285924000000e-06 1.695547000000e-09 6.288562000000e-06 1.700342000000e-09 6.271401000000e-06 1.704014000000e-09 6.279494000000e-06 1.707642000000e-09 6.268238000000e-06 1.712914000000e-09 6.276570000000e-06 1.717024000000e-09 6.266986000000e-06 1.722796000000e-09 6.275269000000e-06 1.724262000000e-09 6.271046000000e-06 1.725743000000e-09 6.270656000000e-06 1.730482000000e-09 6.270676000000e-06 1.734128000000e-09 6.270333000000e-06 1.739613000000e-09 6.270385000000e-06 1.743241000000e-09 6.270073000000e-06 1.746998000000e-09 6.270202000000e-06 1.752400000000e-09 6.269866000000e-06 1.756586000000e-09 6.269996000000e-06 1.762468000000e-09 6.269702000000e-06 1.764025000000e-09 6.269803000000e-06 1.765380000000e-09 6.269751000000e-06 1.769719000000e-09 6.269693000000e-06 1.773264000000e-09 6.269664000000e-06 1.778028000000e-09 6.269614000000e-06 1.781718000000e-09 6.269581000000e-06 1.785310000000e-09 6.269543000000e-06 1.790811000000e-09 6.269499000000e-06 1.794844000000e-09 6.269468000000e-06 1.800637000000e-09 6.269440000000e-06 1.802097000000e-09 6.269442000000e-06 1.803580000000e-09 6.269405000000e-06 1.808326000000e-09 6.269373000000e-06 1.811970000000e-09 6.269365000000e-06 1.817496000000e-09 6.269339000000e-06 1.821120000000e-09 6.269313000000e-06 1.824884000000e-09 6.269303000000e-06 1.830308000000e-09 6.269289000000e-06 1.834495000000e-09 6.269274000000e-06 1.840377000000e-09 6.269258000000e-06 1.841939000000e-09 6.269263000000e-06 1.843284000000e-09 6.269240000000e-06 1.847586000000e-09 6.269224000000e-06 1.851115000000e-09 6.269222000000e-06 1.855851000000e-09 6.269210000000e-06 1.859543000000e-09 6.269202000000e-06 1.863125000000e-09 6.269193000000e-06 1.868621000000e-09 6.269181000000e-06 1.872640000000e-09 6.269174000000e-06 1.878406000000e-09 6.269162000000e-06 1.879857000000e-09 6.269169000000e-06 1.881342000000e-09 6.269154000000e-06 1.886097000000e-09 6.269145000000e-06 1.889729000000e-09 6.269145000000e-06 1.895406000000e-09 6.269137000000e-06 1.899019000000e-09 6.269145000000e-06 1.902802000000e-09 6.269123000000e-06 1.908327000000e-09 6.269117000000e-06 1.912510000000e-09 6.269115000000e-06 1.918396000000e-09 6.269108000000e-06 1.923452000000e-09 6.269104000000e-06 1.928319000000e-09 6.269098000000e-06 1.933832000000e-09 6.269094000000e-06 1.937865000000e-09 6.269091000000e-06 1.941516000000e-09 6.269088000000e-06 1.947123000000e-09 6.269083000000e-06 1.951206000000e-09 6.269081000000e-06 1.957151000000e-09 6.269076000000e-06 1.962202000000e-09 6.269074000000e-06 1.967100000000e-09 6.269070000000e-06 1.968013000000e-09 6.269075000000e-06 1.969099000000e-09 6.269066000000e-06 1.972453000000e-09 6.269067000000e-06 1.975701000000e-09 6.269065000000e-06 1.979195000000e-09 6.269064000000e-06 1.983866000000e-09 6.269061000000e-06 1.987814000000e-09 6.269060000000e-06 1.993099000000e-09 6.269065000000e-06 1.998488000000e-09 6.269044000000e-06 2.003935000000e-09 6.269055000000e-06 2.004866000000e-09 6.269059000000e-06 2.005730000000e-09 6.269052000000e-06 2.008495000000e-09 6.269051000000e-06 2.013208000000e-09 6.269049000000e-06 2.016501000000e-09 6.269048000000e-06 2.021215000000e-09 6.269046000000e-06 2.025252000000e-09 6.269045000000e-06 2.030301000000e-09 6.269043000000e-06 2.035760000000e-09 6.269041000000e-06 2.040977000000e-09 6.269040000000e-06 2.042009000000e-09 6.269043000000e-06 2.042812000000e-09 6.269037000000e-06 2.045379000000e-09 6.269038000000e-06 2.049639000000e-09 6.269037000000e-06 2.053254000000e-09 6.269037000000e-06 2.056728000000e-09 6.269036000000e-06 2.062152000000e-09 6.269034000000e-06 2.066039000000e-09 6.269033000000e-06 2.071558000000e-09 6.269032000000e-06 2.076872000000e-09 6.269031000000e-06 2.078300000000e-09 6.269036000000e-06 2.079144000000e-09 6.269025000000e-06 2.081843000000e-09 6.269029000000e-06 2.085459000000e-09 6.269029000000e-06 2.089564000000e-09 6.269029000000e-06 2.093109000000e-09 6.269028000000e-06 2.096789000000e-09 6.269027000000e-06 2.101106000000e-09 6.269026000000e-06 2.105378000000e-09 6.269026000000e-06 2.110838000000e-09 6.269025000000e-06 2.112251000000e-09 6.269029000000e-06 2.113753000000e-09 6.269019000000e-06 2.118558000000e-09 6.269024000000e-06 2.122133000000e-09 6.269023000000e-06 2.129360000000e-09 6.269022000000e-06 2.132821000000e-09 6.269022000000e-06 2.136929000000e-09 6.269021000000e-06 2.139763000000e-09 6.269021000000e-06 2.142597000000e-09 6.269020000000e-06 2.147012000000e-09 6.269020000000e-06 2.152765000000e-09 6.269019000000e-06 2.154377000000e-09 6.269023000000e-06 2.155442000000e-09 6.269014000000e-06 2.158852000000e-09 6.269018000000e-06 2.162621000000e-09 6.269018000000e-06 2.166944000000e-09 6.269028000000e-06 2.170618000000e-09 6.269013000000e-06 2.174167000000e-09 6.269014000000e-06 2.179170000000e-09 6.269015000000e-06 2.183292000000e-09 6.269015000000e-06 2.188867000000e-09 6.269015000000e-06 2.190278000000e-09 6.269018000000e-06 2.191779000000e-09 6.269011000000e-06 2.196584000000e-09 6.269015000000e-06 2.200169000000e-09 6.269014000000e-06 2.207050000000e-09 6.269014000000e-06 2.210543000000e-09 6.269014000000e-06 2.214570000000e-09 6.269013000000e-06 2.217383000000e-09 6.269013000000e-06 2.220196000000e-09 6.269013000000e-06 2.224548000000e-09 6.269013000000e-06 2.230327000000e-09 6.269012000000e-06 2.231668000000e-09 6.269014000000e-06 2.232487000000e-09 6.269010000000e-06 2.235108000000e-09 6.269011000000e-06 2.238430000000e-09 6.269011000000e-06 2.242101000000e-09 6.269011000000e-06 2.245250000000e-09 6.269011000000e-06 2.248623000000e-09 6.269011000000e-06 2.252399000000e-09 6.269011000000e-06 2.256336000000e-09 6.269010000000e-06 2.261919000000e-09 6.269010000000e-06 2.264384000000e-09 6.269012000000e-06 2.265883000000e-09 6.269011000000e-06 2.270679000000e-09 6.269006000000e-06 2.277378000000e-09 6.269012000000e-06 2.283984000000e-09 6.269009000000e-06 2.291963000000e-09 6.269009000000e-06 2.303337000000e-09 6.269008000000e-06 2.323042000000e-09 6.269007000000e-06 2.352076000000e-09 6.269006000000e-06 2.407975000000e-09 6.269005000000e-06 2.543499000000e-09 6.269002000000e-06 2.778736000000e-09 6.269000000000e-06 3.128736000000e-09 6.268999000000e-06 3.478736000000e-09 6.268999000000e-06 3.828736000000e-09 6.268998000000e-06 4.076000000000e-09 6.268999000000e-06 4.076500000000e-09 2.038875000000e-02 4.077000000000e-09 4.008546000000e-02 4.077306000000e-09 3.906375000000e-02 4.077515000000e-09 3.826672000000e-02 4.078112000000e-09 3.572795000000e-02 4.079900000000e-09 2.851107000000e-02 4.082540000000e-09 1.954757000000e-02 4.086501000000e-09 1.039417000000e-02 4.092049000000e-09 3.780536000000e-03 4.100074000000e-09 6.746018000000e-04 4.112222000000e-09 -3.133277000000e-05 4.128358000000e-09 2.199369000000e-05 4.151784000000e-09 -4.195093000000e-06 4.181738000000e-09 1.635036000000e-05 4.223091000000e-09 -1.031264000000e-06 4.287381000000e-09 1.497423000000e-05 4.412795000000e-09 -6.617168000000e-07 4.639879000000e-09 1.494953000000e-05 4.989879000000e-09 -1.080473000000e-06 5.339879000000e-09 1.531053000000e-05 5.689879000000e-09 -1.381861000000e-06 6.039879000000e-09 1.560324000000e-05 6.389879000000e-09 -1.683354000000e-06 6.739879000000e-09 1.585850000000e-05 7.000000000000e-09 -1.973472000000e-06)
V_XOR_02 xor_02 0 PWL(0.000000000000e+00 6.995221000000e-06 1.000000000000e-12 6.997984000000e-06 2.000000000000e-12 7.000502000000e-06 5.200000000000e-12 7.006871000000e-06 1.544000000000e-11 7.014253000000e-06 4.820800000000e-11 7.014547000000e-06 1.530656000000e-10 7.014629000000e-06 4.886099000000e-10 7.014537000000e-06 8.386099000000e-10 7.014631000000e-06 9.995000000000e-10 7.014537000000e-06 9.996500000000e-10 7.032192000000e-06 1.000130000000e-09 7.042276000000e-06 1.000271000000e-09 7.039833000000e-06 1.000500000000e-09 7.010244000000e-06 1.000549000000e-09 6.997363000000e-06 1.000579000000e-09 6.989078000000e-06 1.000674000000e-09 6.955730000000e-06 1.000921000000e-09 6.892799000000e-06 1.001177000000e-09 6.894853000000e-06 1.001636000000e-09 6.948735000000e-06 1.002995000000e-09 7.076349000000e-06 1.004717000000e-09 7.100105000000e-06 1.007157000000e-09 7.057158000000e-06 1.009530000000e-09 6.943172000000e-06 1.012064000000e-09 6.808101000000e-06 1.014479000000e-09 6.692422000000e-06 1.016999000000e-09 6.720430000000e-06 1.019780000000e-09 7.298144000000e-06 1.023006000000e-09 1.110403000000e-05 1.025715000000e-09 1.348958000000e-05 1.028767000000e-09 2.689777000000e-06 1.031545000000e-09 -3.212627000000e-05 1.034548000000e-09 -8.372152000000e-05 1.037295000000e-09 -7.572188000000e-05 1.040188000000e-09 3.018200000000e-04 1.042931000000e-09 1.073067000000e-03 1.046095000000e-09 1.245962000000e-03 1.049020000000e-09 -2.166752000000e-03 1.051920000000e-09 -1.108487000000e-02 1.055268000000e-09 -2.142466000000e-02 1.057963000000e-09 -7.263207000000e-03 1.059420000000e-09 1.972585000000e-02 1.060877000000e-09 6.028451000000e-02 1.063981000000e-09 1.743970000000e-01 1.066813000000e-09 2.771183000000e-01 1.069715000000e-09 3.680149000000e-01 1.073141000000e-09 4.731129000000e-01 1.075000000000e-09 5.320048000000e-01 1.075500000000e-09 5.247245000000e-01 1.075834000000e-09 5.194215000000e-01 1.076000000000e-09 5.166041000000e-01 1.076266000000e-09 5.239266000000e-01 1.076419000000e-09 5.282062000000e-01 1.076822000000e-09 5.393399000000e-01 1.078112000000e-09 5.717940000000e-01 1.079915000000e-09 6.108617000000e-01 1.082834000000e-09 6.618746000000e-01 1.086452000000e-09 7.081743000000e-01 1.089863000000e-09 7.390354000000e-01 1.094093000000e-09 7.657177000000e-01 1.097558000000e-09 7.821817000000e-01 1.101264000000e-09 7.980924000000e-01 1.105520000000e-09 8.143003000000e-01 1.109056000000e-09 8.251856000000e-01 1.112992000000e-09 8.344366000000e-01 1.115807000000e-09 8.394327000000e-01 1.118621000000e-09 8.430802000000e-01 1.121942000000e-09 8.462532000000e-01 1.125724000000e-09 8.491244000000e-01 1.129501000000e-09 8.513916000000e-01 1.133249000000e-09 8.531016000000e-01 1.135809000000e-09 8.539810000000e-01 1.138369000000e-09 8.546263000000e-01 1.141791000000e-09 8.552944000000e-01 1.145734000000e-09 8.557692000000e-01 1.150017000000e-09 8.559273000000e-01 1.153865000000e-09 8.557853000000e-01 1.158361000000e-09 8.548577000000e-01 1.161824000000e-09 8.538228000000e-01 1.165535000000e-09 8.569582000000e-01 1.169527000000e-09 8.698230000000e-01 1.173109000000e-09 8.871636000000e-01 1.177056000000e-09 9.046154000000e-01 1.179535000000e-09 9.036873000000e-01 1.182013000000e-09 8.935892000000e-01 1.185429000000e-09 8.352381000000e-01 1.189651000000e-09 6.936714000000e-01 1.193349000000e-09 5.338484000000e-01 1.197208000000e-09 3.710575000000e-01 1.200595000000e-09 2.532265000000e-01 1.204042000000e-09 1.614504000000e-01 1.207661000000e-09 9.971612000000e-02 1.212044000000e-09 5.801029000000e-02 1.215603000000e-09 4.003944000000e-02 1.219624000000e-09 2.888526000000e-02 1.222280000000e-09 2.382557000000e-02 1.224935000000e-09 2.060004000000e-02 1.228316000000e-09 1.650382000000e-02 1.229186000000e-09 1.543777000000e-02 1.230042000000e-09 1.441317000000e-02 1.232779000000e-09 1.134177000000e-02 1.235670000000e-09 8.535553000000e-03 1.238863000000e-09 6.059866000000e-03 1.243639000000e-09 3.496128000000e-03 1.246999000000e-09 2.384558000000e-03 1.250850000000e-09 1.582728000000e-03 1.255187000000e-09 1.047484000000e-03 1.258822000000e-09 7.842251000000e-04 1.259631000000e-09 7.438381000000e-04 1.260438000000e-09 7.058663000000e-04 1.263021000000e-09 6.100368000000e-04 1.265957000000e-09 5.427557000000e-04 1.269137000000e-09 5.177213000000e-04 1.273131000000e-09 5.573060000000e-04 1.276658000000e-09 6.353501000000e-04 1.280195000000e-09 7.258987000000e-04 1.284359000000e-09 8.314689000000e-04 1.288216000000e-09 9.082326000000e-04 1.291735000000e-09 9.416921000000e-04 1.292574000000e-09 9.418146000000e-04 1.293423000000e-09 9.407735000000e-04 1.296139000000e-09 9.229164000000e-04 1.299136000000e-09 8.810093000000e-04 1.302736000000e-09 8.088659000000e-04 1.306959000000e-09 7.080060000000e-04 1.310392000000e-09 6.219029000000e-04 1.314112000000e-09 5.316140000000e-04 1.317424000000e-09 4.570813000000e-04 1.320972000000e-09 3.851667000000e-04 1.324632000000e-09 3.202495000000e-04 1.327145000000e-09 2.809582000000e-04 1.329658000000e-09 2.459701000000e-04 1.333049000000e-09 2.048996000000e-04 1.337028000000e-09 1.648069000000e-04 1.341293000000e-09 1.302104000000e-04 1.345153000000e-09 1.051501000000e-04 1.349994000000e-09 8.045368000000e-05 1.353616000000e-09 6.601406000000e-05 1.357116000000e-09 5.468290000000e-05 1.357983000000e-09 5.228108000000e-05 1.358962000000e-09 4.965106000000e-05 1.362092000000e-09 4.217118000000e-05 1.364885000000e-09 3.658068000000e-05 1.369987000000e-09 2.845765000000e-05 1.373500000000e-09 2.417240000000e-05 1.377230000000e-09 2.051525000000e-05 1.381288000000e-09 1.737188000000e-05 1.384815000000e-09 1.520755000000e-05 1.388662000000e-09 1.332095000000e-05 1.389532000000e-09 1.296293000000e-05 1.390483000000e-09 1.258255000000e-05 1.393528000000e-09 1.150117000000e-05 1.396267000000e-09 1.068716000000e-05 1.399530000000e-09 9.878813000000e-06 1.403009000000e-09 9.177611000000e-06 1.406745000000e-09 8.573326000000e-06 1.410579000000e-09 8.081808000000e-06 1.413057000000e-09 7.817350000000e-06 1.415535000000e-09 7.594734000000e-06 1.418933000000e-09 7.338114000000e-06 1.419781000000e-09 7.283556000000e-06 1.420563000000e-09 7.234468000000e-06 1.423064000000e-09 7.092052000000e-06 1.426220000000e-09 6.940123000000e-06 1.429627000000e-09 6.806401000000e-06 1.432942000000e-09 6.700971000000e-06 1.436511000000e-09 6.608736000000e-06 1.439973000000e-09 6.536718000000e-06 1.444113000000e-09 6.468475000000e-06 1.447667000000e-09 6.422302000000e-06 1.448597000000e-09 6.412142000000e-06 1.449278000000e-09 6.404841000000e-06 1.451458000000e-09 6.383398000000e-06 1.454984000000e-09 6.354180000000e-06 1.458241000000e-09 6.332294000000e-06 1.461761000000e-09 6.313078000000e-06 1.465886000000e-09 6.295241000000e-06 1.469389000000e-09 6.283295000000e-06 1.472794000000e-09 6.273909000000e-06 1.475276000000e-09 6.268138000000e-06 1.477758000000e-09 6.263272000000e-06 1.479095000000e-09 6.261026000000e-06 1.479882000000e-09 6.259735000000e-06 1.482402000000e-09 6.255992000000e-06 1.485321000000e-09 6.252320000000e-06 1.488790000000e-09 6.248727000000e-06 1.492381000000e-09 6.245734000000e-06 1.496661000000e-09 6.242927000000e-06 1.500576000000e-09 6.240936000000e-06 1.504103000000e-09 6.239510000000e-06 1.508121000000e-09 6.238219000000e-06 1.509046000000e-09 6.237973000000e-06 1.509764000000e-09 6.237786000000e-06 1.512062000000e-09 6.237240000000e-06 1.514727000000e-09 6.236694000000e-06 1.518391000000e-09 6.236076000000e-06 1.521668000000e-09 6.235629000000e-06 1.525243000000e-09 6.235234000000e-06 1.529365000000e-09 6.234875000000e-06 1.532875000000e-09 6.234633000000e-06 1.534025000000e-09 6.234565000000e-06 1.534117000000e-09 -1.334584000000e-03 1.534180000000e-09 -2.241856000000e-03 1.534382000000e-09 -4.853418000000e-03 1.534737000000e-09 -8.569269000000e-03 1.535025000000e-09 -1.069752000000e-02 1.535086000000e-09 -1.023677000000e-02 1.535120000000e-09 -9.976150000000e-03 1.535227000000e-09 -9.181690000000e-03 1.535516000000e-09 -7.270695000000e-03 1.535770000000e-09 -5.872650000000e-03 1.536253000000e-09 -3.758942000000e-03 1.537797000000e-09 2.291808000000e-04 1.540037000000e-09 2.428642000000e-03 1.542991000000e-09 2.670917000000e-03 1.546340000000e-09 1.529333000000e-03 1.549563000000e-09 5.587355000000e-04 1.553023000000e-09 -8.552182000000e-05 1.556674000000e-09 -3.334931000000e-04 1.561332000000e-09 -2.896483000000e-04 1.564959000000e-09 -1.784191000000e-04 1.568637000000e-09 -9.940809000000e-05 1.572862000000e-09 -4.713211000000e-05 1.576410000000e-09 -2.368884000000e-05 1.580380000000e-09 -7.872652000000e-06 1.584817000000e-09 -2.045719000000e-06 1.588226000000e-09 3.474941000000e-06 1.592181000000e-09 3.169801000000e-06 1.595925000000e-09 6.501767000000e-06 1.599741000000e-09 4.716012000000e-06 1.604581000000e-09 7.406784000000e-06 1.606342000000e-09 6.706521000000e-06 1.608103000000e-09 5.110493000000e-06 1.611836000000e-09 7.602088000000e-06 1.616035000000e-09 5.157814000000e-06 1.619218000000e-09 7.673522000000e-06 1.623182000000e-09 5.123783000000e-06 1.626358000000e-09 7.708004000000e-06 1.629985000000e-09 5.078998000000e-06 1.634074000000e-09 7.724827000000e-06 1.638238000000e-09 5.032279000000e-06 1.643068000000e-09 7.750716000000e-06 1.648476000000e-09 4.960674000000e-06 1.653917000000e-09 7.740305000000e-06 1.658595000000e-09 4.924507000000e-06 1.665047000000e-09 7.746053000000e-06 1.668427000000e-09 4.899851000000e-06 1.674362000000e-09 7.766960000000e-06 1.678501000000e-09 4.878314000000e-06 1.684581000000e-09 7.775890000000e-06 1.686093000000e-09 6.300688000000e-06 1.687486000000e-09 6.320526000000e-06 1.691945000000e-09 6.285921000000e-06 1.695547000000e-09 6.288595000000e-06 1.700342000000e-09 6.271387000000e-06 1.704014000000e-09 6.279524000000e-06 1.707642000000e-09 6.268229000000e-06 1.712914000000e-09 6.276604000000e-06 1.717024000000e-09 6.266982000000e-06 1.722796000000e-09 6.275305000000e-06 1.724262000000e-09 6.271063000000e-06 1.725743000000e-09 6.270673000000e-06 1.730482000000e-09 6.270694000000e-06 1.734128000000e-09 6.270350000000e-06 1.739613000000e-09 6.270403000000e-06 1.743241000000e-09 6.270090000000e-06 1.746998000000e-09 6.270220000000e-06 1.752400000000e-09 6.269884000000e-06 1.756586000000e-09 6.270014000000e-06 1.762468000000e-09 6.269719000000e-06 1.764025000000e-09 6.269821000000e-06 1.765380000000e-09 6.269769000000e-06 1.769719000000e-09 6.269711000000e-06 1.773264000000e-09 6.269682000000e-06 1.778028000000e-09 6.269632000000e-06 1.781718000000e-09 6.269598000000e-06 1.785310000000e-09 6.269561000000e-06 1.790811000000e-09 6.269517000000e-06 1.794844000000e-09 6.269486000000e-06 1.800637000000e-09 6.269457000000e-06 1.802097000000e-09 6.269460000000e-06 1.803580000000e-09 6.269423000000e-06 1.808326000000e-09 6.269390000000e-06 1.811970000000e-09 6.269383000000e-06 1.817496000000e-09 6.269357000000e-06 1.821120000000e-09 6.269331000000e-06 1.824884000000e-09 6.269321000000e-06 1.830308000000e-09 6.269307000000e-06 1.834495000000e-09 6.269292000000e-06 1.840377000000e-09 6.269276000000e-06 1.841939000000e-09 6.269281000000e-06 1.843284000000e-09 6.269258000000e-06 1.847586000000e-09 6.269241000000e-06 1.851115000000e-09 6.269239000000e-06 1.855851000000e-09 6.269228000000e-06 1.859543000000e-09 6.269219000000e-06 1.863125000000e-09 6.269211000000e-06 1.868621000000e-09 6.269198000000e-06 1.872640000000e-09 6.269191000000e-06 1.878406000000e-09 6.269180000000e-06 1.879857000000e-09 6.269186000000e-06 1.881342000000e-09 6.269172000000e-06 1.886097000000e-09 6.269163000000e-06 1.889729000000e-09 6.269162000000e-06 1.895406000000e-09 6.269154000000e-06 1.899019000000e-09 6.269162000000e-06 1.902802000000e-09 6.269141000000e-06 1.908327000000e-09 6.269135000000e-06 1.912510000000e-09 6.269132000000e-06 1.918396000000e-09 6.269125000000e-06 1.923452000000e-09 6.269122000000e-06 1.928319000000e-09 6.269116000000e-06 1.933832000000e-09 6.269112000000e-06 1.937865000000e-09 6.269108000000e-06 1.941516000000e-09 6.269106000000e-06 1.947123000000e-09 6.269100000000e-06 1.951206000000e-09 6.269099000000e-06 1.957151000000e-09 6.269094000000e-06 1.962202000000e-09 6.269091000000e-06 1.967100000000e-09 6.269088000000e-06 1.968013000000e-09 6.269093000000e-06 1.969099000000e-09 6.269083000000e-06 1.972453000000e-09 6.269084000000e-06 1.975701000000e-09 6.269083000000e-06 1.979195000000e-09 6.269081000000e-06 1.983866000000e-09 6.269079000000e-06 1.987814000000e-09 6.269077000000e-06 1.993099000000e-09 6.269083000000e-06 1.998488000000e-09 6.269062000000e-06 2.003935000000e-09 6.269072000000e-06 2.004866000000e-09 6.269077000000e-06 2.005730000000e-09 6.269070000000e-06 2.008495000000e-09 6.269069000000e-06 2.013208000000e-09 6.269066000000e-06 2.016501000000e-09 6.269065000000e-06 2.021215000000e-09 6.269063000000e-06 2.025252000000e-09 6.269062000000e-06 2.030301000000e-09 6.269060000000e-06 2.035760000000e-09 6.269059000000e-06 2.040977000000e-09 6.269057000000e-06 2.042009000000e-09 6.269061000000e-06 2.042812000000e-09 6.269054000000e-06 2.045379000000e-09 6.269055000000e-06 2.049639000000e-09 6.269055000000e-06 2.053254000000e-09 6.269054000000e-06 2.056728000000e-09 6.269053000000e-06 2.062152000000e-09 6.269052000000e-06 2.066039000000e-09 6.269051000000e-06 2.071558000000e-09 6.269049000000e-06 2.076872000000e-09 6.269049000000e-06 2.078300000000e-09 6.269053000000e-06 2.079144000000e-09 6.269043000000e-06 2.081843000000e-09 6.269047000000e-06 2.085459000000e-09 6.269047000000e-06 2.089564000000e-09 6.269046000000e-06 2.093109000000e-09 6.269045000000e-06 2.096789000000e-09 6.269045000000e-06 2.101106000000e-09 6.269044000000e-06 2.105378000000e-09 6.269043000000e-06 2.110838000000e-09 6.269042000000e-06 2.112251000000e-09 6.269046000000e-06 2.113753000000e-09 6.269037000000e-06 2.118558000000e-09 6.269042000000e-06 2.122133000000e-09 6.269041000000e-06 2.129360000000e-09 6.269040000000e-06 2.132821000000e-09 6.269039000000e-06 2.136929000000e-09 6.269039000000e-06 2.139763000000e-09 6.269038000000e-06 2.142597000000e-09 6.269038000000e-06 2.147012000000e-09 6.269037000000e-06 2.152765000000e-09 6.269037000000e-06 2.154377000000e-09 6.269040000000e-06 2.155442000000e-09 6.269031000000e-06 2.158852000000e-09 6.269036000000e-06 2.162621000000e-09 6.269035000000e-06 2.166944000000e-09 6.269046000000e-06 2.170618000000e-09 6.269031000000e-06 2.174167000000e-09 6.269031000000e-06 2.179170000000e-09 6.269033000000e-06 2.183292000000e-09 6.269032000000e-06 2.188867000000e-09 6.269033000000e-06 2.190278000000e-09 6.269036000000e-06 2.191779000000e-09 6.269029000000e-06 2.196584000000e-09 6.269033000000e-06 2.200169000000e-09 6.269032000000e-06 2.207050000000e-09 6.269032000000e-06 2.210543000000e-09 6.269031000000e-06 2.214570000000e-09 6.269031000000e-06 2.217383000000e-09 6.269031000000e-06 2.220196000000e-09 6.269030000000e-06 2.224548000000e-09 6.269030000000e-06 2.230327000000e-09 6.269030000000e-06 2.231668000000e-09 6.269032000000e-06 2.232487000000e-09 6.269027000000e-06 2.235108000000e-09 6.269029000000e-06 2.238430000000e-09 6.269029000000e-06 2.242101000000e-09 6.269029000000e-06 2.245250000000e-09 6.269029000000e-06 2.248623000000e-09 6.269029000000e-06 2.252399000000e-09 6.269028000000e-06 2.256336000000e-09 6.269028000000e-06 2.261919000000e-09 6.269028000000e-06 2.264384000000e-09 6.269030000000e-06 2.265883000000e-09 6.269028000000e-06 2.270679000000e-09 6.269023000000e-06 2.277378000000e-09 6.269029000000e-06 2.283984000000e-09 6.269026000000e-06 2.291963000000e-09 6.269026000000e-06 2.303337000000e-09 6.269025000000e-06 2.323042000000e-09 6.269025000000e-06 2.352076000000e-09 6.269024000000e-06 2.407975000000e-09 6.269022000000e-06 2.543499000000e-09 6.269020000000e-06 2.778736000000e-09 6.269018000000e-06 3.128736000000e-09 6.269017000000e-06 3.478736000000e-09 6.269016000000e-06 3.828736000000e-09 6.269016000000e-06 4.076000000000e-09 6.269016000000e-06 4.076500000000e-09 2.038904000000e-02 4.077000000000e-09 4.008576000000e-02 4.077306000000e-09 3.906387000000e-02 4.077515000000e-09 3.826671000000e-02 4.078112000000e-09 3.572770000000e-02 4.079900000000e-09 2.851080000000e-02 4.082540000000e-09 1.954769000000e-02 4.086501000000e-09 1.039432000000e-02 4.092049000000e-09 3.780496000000e-03 4.100074000000e-09 6.745990000000e-04 4.112222000000e-09 -3.133877000000e-05 4.128358000000e-09 2.199700000000e-05 4.151784000000e-09 -4.194297000000e-06 4.181738000000e-09 1.635063000000e-05 4.223091000000e-09 -1.026709000000e-06 4.287381000000e-09 1.497400000000e-05 4.412795000000e-09 -6.563387000000e-07 4.639879000000e-09 1.494894000000e-05 4.989879000000e-09 -1.075026000000e-06 5.339879000000e-09 1.531034000000e-05 5.689879000000e-09 -1.376553000000e-06 6.039879000000e-09 1.560334000000e-05 6.389879000000e-09 -1.678095000000e-06 6.739879000000e-09 1.585886000000e-05 7.000000000000e-09 -1.968233000000e-06)
V_XOR_03 xor_03 0 PWL(0.000000000000e+00 6.995221000000e-06 1.000000000000e-12 6.997984000000e-06 2.000000000000e-12 7.000502000000e-06 5.200000000000e-12 7.006871000000e-06 1.544000000000e-11 7.014253000000e-06 4.820800000000e-11 7.014547000000e-06 1.530656000000e-10 7.014629000000e-06 4.886099000000e-10 7.014537000000e-06 8.386099000000e-10 7.014631000000e-06 9.995000000000e-10 7.014537000000e-06 9.996500000000e-10 7.014976000000e-06 1.000130000000e-09 7.015058000000e-06 1.000271000000e-09 7.014940000000e-06 1.000500000000e-09 7.014075000000e-06 1.000549000000e-09 7.013735000000e-06 1.000579000000e-09 7.013516000000e-06 1.000674000000e-09 7.012662000000e-06 1.000921000000e-09 7.011260000000e-06 1.001177000000e-09 7.012037000000e-06 1.001636000000e-09 7.014507000000e-06 1.002995000000e-09 7.017016000000e-06 1.004717000000e-09 7.015004000000e-06 1.007157000000e-09 7.013533000000e-06 1.009530000000e-09 7.013094000000e-06 1.012064000000e-09 7.013582000000e-06 1.014479000000e-09 7.014261000000e-06 1.016999000000e-09 7.016169000000e-06 1.019780000000e-09 7.021471000000e-06 1.023006000000e-09 7.047686000000e-06 1.025715000000e-09 7.020175000000e-06 1.028767000000e-09 6.874834000000e-06 1.031545000000e-09 6.679392000000e-06 1.034548000000e-09 6.733550000000e-06 1.037295000000e-09 7.559841000000e-06 1.040188000000e-09 1.150283000000e-05 1.042931000000e-09 1.340772000000e-05 1.046095000000e-09 3.873804000000e-07 1.049020000000e-09 -3.901717000000e-05 1.051920000000e-09 -8.823499000000e-05 1.055268000000e-09 -5.323942000000e-06 1.057963000000e-09 4.772842000000e-04 1.059420000000e-09 8.435748000000e-04 1.060877000000e-09 1.283777000000e-03 1.063981000000e-09 7.496293000000e-04 1.066813000000e-09 -3.968931000000e-03 1.069715000000e-09 -1.414129000000e-02 1.073141000000e-09 -1.914192000000e-02 1.075000000000e-09 -6.422854000000e-03 1.075500000000e-09 -2.053524000000e-02 1.075834000000e-09 -2.961215000000e-02 1.076000000000e-09 -3.396916000000e-02 1.076266000000e-09 -2.902642000000e-02 1.076419000000e-09 -2.605495000000e-02 1.076822000000e-09 -1.753998000000e-02 1.078112000000e-09 1.360944000000e-02 1.079915000000e-09 6.446674000000e-02 1.082834000000e-09 1.514581000000e-01 1.086452000000e-09 2.464372000000e-01 1.089863000000e-09 3.200860000000e-01 1.094093000000e-09 4.126057000000e-01 1.097558000000e-09 4.945409000000e-01 1.101264000000e-09 5.781708000000e-01 1.105520000000e-09 6.560924000000e-01 1.109056000000e-09 7.025357000000e-01 1.112992000000e-09 7.387366000000e-01 1.115807000000e-09 7.584253000000e-01 1.118621000000e-09 7.729516000000e-01 1.121942000000e-09 7.884694000000e-01 1.125724000000e-09 8.047566000000e-01 1.129501000000e-09 8.184181000000e-01 1.133249000000e-09 8.290393000000e-01 1.135809000000e-09 8.347287000000e-01 1.138369000000e-09 8.391489000000e-01 1.141791000000e-09 8.435034000000e-01 1.145734000000e-09 8.471139000000e-01 1.150017000000e-09 8.501101000000e-01 1.153865000000e-09 8.521177000000e-01 1.158361000000e-09 8.537895000000e-01 1.161824000000e-09 8.546699000000e-01 1.165535000000e-09 8.555136000000e-01 1.169527000000e-09 8.563800000000e-01 1.173109000000e-09 8.570539000000e-01 1.177056000000e-09 8.576342000000e-01 1.179535000000e-09 8.579112000000e-01 1.182013000000e-09 8.581209000000e-01 1.185429000000e-09 8.581517000000e-01 1.189651000000e-09 8.578560000000e-01 1.193349000000e-09 8.573601000000e-01 1.197208000000e-09 8.562040000000e-01 1.200595000000e-09 8.549434000000e-01 1.204042000000e-09 8.572867000000e-01 1.207661000000e-09 8.678686000000e-01 1.212044000000e-09 8.882968000000e-01 1.215603000000e-09 9.042792000000e-01 1.219624000000e-09 9.046596000000e-01 1.222280000000e-09 8.739298000000e-01 1.224935000000e-09 8.185566000000e-01 1.228316000000e-09 7.002560000000e-01 1.229186000000e-09 6.637768000000e-01 1.230042000000e-09 6.271715000000e-01 1.232779000000e-09 5.058039000000e-01 1.235670000000e-09 3.839849000000e-01 1.238863000000e-09 2.704539000000e-01 1.243639000000e-09 1.459952000000e-01 1.246999000000e-09 9.376309000000e-02 1.250850000000e-09 5.847380000000e-02 1.255187000000e-09 3.734936000000e-02 1.258822000000e-09 2.820315000000e-02 1.259631000000e-09 2.685847000000e-02 1.260438000000e-09 2.556890000000e-02 1.263021000000e-09 2.187496000000e-02 1.265957000000e-09 1.805605000000e-02 1.269137000000e-09 1.412403000000e-02 1.273131000000e-09 9.796546000000e-03 1.276658000000e-09 6.778770000000e-03 1.280195000000e-09 4.559989000000e-03 1.284359000000e-09 2.823237000000e-03 1.288216000000e-09 1.848242000000e-03 1.291735000000e-09 1.298680000000e-03 1.292574000000e-09 1.206712000000e-03 1.293423000000e-09 1.118221000000e-03 1.296139000000e-09 8.902145000000e-04 1.299136000000e-09 7.177595000000e-04 1.302736000000e-09 5.882419000000e-04 1.306959000000e-09 5.204955000000e-04 1.310392000000e-09 5.322227000000e-04 1.314112000000e-09 6.001572000000e-04 1.317424000000e-09 6.821831000000e-04 1.320972000000e-09 7.745822000000e-04 1.324632000000e-09 8.627664000000e-04 1.327145000000e-09 9.066105000000e-04 1.329658000000e-09 9.368501000000e-04 1.333049000000e-09 9.414167000000e-04 1.337028000000e-09 9.005394000000e-04 1.341293000000e-09 8.187288000000e-04 1.345153000000e-09 7.262862000000e-04 1.349994000000e-09 6.048202000000e-04 1.353616000000e-09 5.174626000000e-04 1.357116000000e-09 4.399345000000e-04 1.357983000000e-09 4.222190000000e-04 1.358962000000e-09 4.025942000000e-04 1.362092000000e-09 3.444325000000e-04 1.364885000000e-09 2.984263000000e-04 1.369987000000e-09 2.277028000000e-04 1.373500000000e-09 1.882147000000e-04 1.377230000000e-09 1.533492000000e-04 1.381288000000e-09 1.225211000000e-04 1.384815000000e-09 1.007945000000e-04 1.388662000000e-09 8.152732000000e-05 1.389532000000e-09 7.782762000000e-05 1.390483000000e-09 7.389053000000e-05 1.393528000000e-09 6.263090000000e-05 1.396267000000e-09 5.408310000000e-05 1.399530000000e-09 4.553537000000e-05 1.403009000000e-09 3.807138000000e-05 1.406745000000e-09 3.160390000000e-05 1.410579000000e-09 2.631770000000e-05 1.413057000000e-09 2.346522000000e-05 1.415535000000e-09 2.105625000000e-05 1.418933000000e-09 1.827424000000e-05 1.419781000000e-09 1.768176000000e-05 1.420563000000e-09 1.714859000000e-05 1.423064000000e-09 1.560085000000e-05 1.426220000000e-09 1.395405000000e-05 1.429627000000e-09 1.249766000000e-05 1.432942000000e-09 1.134394000000e-05 1.436511000000e-09 1.033739000000e-05 1.439973000000e-09 9.550549000000e-06 1.444113000000e-09 8.804174000000e-06 1.447667000000e-09 8.299184000000e-06 1.448597000000e-09 8.187746000000e-06 1.449278000000e-09 8.107754000000e-06 1.451458000000e-09 7.872802000000e-06 1.454984000000e-09 7.552606000000e-06 1.458241000000e-09 7.312743000000e-06 1.461761000000e-09 7.102048000000e-06 1.465886000000e-09 6.906452000000e-06 1.469389000000e-09 6.775424000000e-06 1.472794000000e-09 6.672462000000e-06 1.475276000000e-09 6.609160000000e-06 1.477758000000e-09 6.555763000000e-06 1.479095000000e-09 6.531123000000e-06 1.479882000000e-09 6.516957000000e-06 1.482402000000e-09 6.475890000000e-06 1.485321000000e-09 6.435590000000e-06 1.488790000000e-09 6.396160000000e-06 1.492381000000e-09 6.363304000000e-06 1.496661000000e-09 6.332492000000e-06 1.500576000000e-09 6.310621000000e-06 1.504103000000e-09 6.294974000000e-06 1.508121000000e-09 6.280820000000e-06 1.509046000000e-09 6.278114000000e-06 1.509764000000e-09 6.276061000000e-06 1.512062000000e-09 6.270056000000e-06 1.514727000000e-09 6.263528000000e-06 1.518391000000e-09 6.256363000000e-06 1.521668000000e-09 6.251752000000e-06 1.525243000000e-09 6.247586000000e-06 1.529365000000e-09 6.243735000000e-06 1.532875000000e-09 6.241176000000e-06 1.534025000000e-09 6.240422000000e-06 1.534117000000e-09 -1.334590000000e-03 1.534180000000e-09 -2.241863000000e-03 1.534382000000e-09 -4.853423000000e-03 1.534737000000e-09 -8.569272000000e-03 1.535025000000e-09 -1.069752000000e-02 1.535086000000e-09 -1.023677000000e-02 1.535120000000e-09 -9.976147000000e-03 1.535227000000e-09 -9.181685000000e-03 1.535516000000e-09 -7.270684000000e-03 1.535770000000e-09 -5.872637000000e-03 1.536253000000e-09 -3.758926000000e-03 1.537797000000e-09 2.291971000000e-04 1.540037000000e-09 2.428671000000e-03 1.542991000000e-09 2.670941000000e-03 1.546340000000e-09 1.529307000000e-03 1.549563000000e-09 5.587121000000e-04 1.553023000000e-09 -8.551652000000e-05 1.556674000000e-09 -3.334825000000e-04 1.561332000000e-09 -2.896443000000e-04 1.564959000000e-09 -1.784191000000e-04 1.568637000000e-09 -9.940843000000e-05 1.572862000000e-09 -4.713295000000e-05 1.576410000000e-09 -2.368898000000e-05 1.580380000000e-09 -7.873160000000e-06 1.584817000000e-09 -2.045609000000e-06 1.588226000000e-09 3.474621000000e-06 1.592181000000e-09 3.169977000000e-06 1.595925000000e-09 6.501500000000e-06 1.599741000000e-09 4.716213000000e-06 1.604581000000e-09 7.406558000000e-06 1.606342000000e-09 6.706392000000e-06 1.608103000000e-09 5.110597000000e-06 1.611836000000e-09 7.601953000000e-06 1.616035000000e-09 5.158072000000e-06 1.619218000000e-09 7.673323000000e-06 1.623182000000e-09 5.123961000000e-06 1.626358000000e-09 7.707824000000e-06 1.629985000000e-09 5.079174000000e-06 1.634074000000e-09 7.724572000000e-06 1.638238000000e-09 5.032624000000e-06 1.643068000000e-09 7.750453000000e-06 1.648476000000e-09 4.960865000000e-06 1.653917000000e-09 7.740150000000e-06 1.658595000000e-09 4.924665000000e-06 1.665047000000e-09 7.745908000000e-06 1.668427000000e-09 4.900002000000e-06 1.674362000000e-09 7.766826000000e-06 1.678501000000e-09 4.878457000000e-06 1.684581000000e-09 7.775762000000e-06 1.686093000000e-09 6.300689000000e-06 1.687486000000e-09 6.320532000000e-06 1.691945000000e-09 6.285918000000e-06 1.695547000000e-09 6.288598000000e-06 1.700342000000e-09 6.271386000000e-06 1.704014000000e-09 6.279528000000e-06 1.707642000000e-09 6.268229000000e-06 1.712914000000e-09 6.276608000000e-06 1.717024000000e-09 6.266981000000e-06 1.722796000000e-09 6.275309000000e-06 1.724262000000e-09 6.271064000000e-06 1.725743000000e-09 6.270674000000e-06 1.730482000000e-09 6.270695000000e-06 1.734128000000e-09 6.270352000000e-06 1.739613000000e-09 6.270404000000e-06 1.743241000000e-09 6.270091000000e-06 1.746998000000e-09 6.270221000000e-06 1.752400000000e-09 6.269885000000e-06 1.756586000000e-09 6.270016000000e-06 1.762468000000e-09 6.269721000000e-06 1.764025000000e-09 6.269823000000e-06 1.765380000000e-09 6.269770000000e-06 1.769719000000e-09 6.269712000000e-06 1.773264000000e-09 6.269684000000e-06 1.778028000000e-09 6.269634000000e-06 1.781718000000e-09 6.269600000000e-06 1.785310000000e-09 6.269563000000e-06 1.790811000000e-09 6.269518000000e-06 1.794844000000e-09 6.269488000000e-06 1.800637000000e-09 6.269459000000e-06 1.802097000000e-09 6.269461000000e-06 1.803580000000e-09 6.269425000000e-06 1.808326000000e-09 6.269392000000e-06 1.811970000000e-09 6.269385000000e-06 1.817496000000e-09 6.269358000000e-06 1.821120000000e-09 6.269333000000e-06 1.824884000000e-09 6.269323000000e-06 1.830308000000e-09 6.269309000000e-06 1.834495000000e-09 6.269293000000e-06 1.840377000000e-09 6.269277000000e-06 1.841939000000e-09 6.269283000000e-06 1.843284000000e-09 6.269260000000e-06 1.847586000000e-09 6.269243000000e-06 1.851115000000e-09 6.269241000000e-06 1.855851000000e-09 6.269230000000e-06 1.859543000000e-09 6.269221000000e-06 1.863125000000e-09 6.269213000000e-06 1.868621000000e-09 6.269200000000e-06 1.872640000000e-09 6.269193000000e-06 1.878406000000e-09 6.269182000000e-06 1.879857000000e-09 6.269188000000e-06 1.881342000000e-09 6.269173000000e-06 1.886097000000e-09 6.269165000000e-06 1.889729000000e-09 6.269164000000e-06 1.895406000000e-09 6.269156000000e-06 1.899019000000e-09 6.269164000000e-06 1.902802000000e-09 6.269142000000e-06 1.908327000000e-09 6.269137000000e-06 1.912510000000e-09 6.269134000000e-06 1.918396000000e-09 6.269127000000e-06 1.923452000000e-09 6.269123000000e-06 1.928319000000e-09 6.269118000000e-06 1.933832000000e-09 6.269114000000e-06 1.937865000000e-09 6.269110000000e-06 1.941516000000e-09 6.269108000000e-06 1.947123000000e-09 6.269102000000e-06 1.951206000000e-09 6.269100000000e-06 1.957151000000e-09 6.269095000000e-06 1.962202000000e-09 6.269093000000e-06 1.967100000000e-09 6.269089000000e-06 1.968013000000e-09 6.269094000000e-06 1.969099000000e-09 6.269085000000e-06 1.972453000000e-09 6.269086000000e-06 1.975701000000e-09 6.269085000000e-06 1.979195000000e-09 6.269083000000e-06 1.983866000000e-09 6.269081000000e-06 1.987814000000e-09 6.269079000000e-06 1.993099000000e-09 6.269084000000e-06 1.998488000000e-09 6.269064000000e-06 2.003935000000e-09 6.269074000000e-06 2.004866000000e-09 6.269078000000e-06 2.005730000000e-09 6.269071000000e-06 2.008495000000e-09 6.269071000000e-06 2.013208000000e-09 6.269068000000e-06 2.016501000000e-09 6.269067000000e-06 2.021215000000e-09 6.269065000000e-06 2.025252000000e-09 6.269064000000e-06 2.030301000000e-09 6.269062000000e-06 2.035760000000e-09 6.269060000000e-06 2.040977000000e-09 6.269059000000e-06 2.042009000000e-09 6.269063000000e-06 2.042812000000e-09 6.269056000000e-06 2.045379000000e-09 6.269057000000e-06 2.049639000000e-09 6.269056000000e-06 2.053254000000e-09 6.269056000000e-06 2.056728000000e-09 6.269055000000e-06 2.062152000000e-09 6.269053000000e-06 2.066039000000e-09 6.269053000000e-06 2.071558000000e-09 6.269051000000e-06 2.076872000000e-09 6.269050000000e-06 2.078300000000e-09 6.269055000000e-06 2.079144000000e-09 6.269045000000e-06 2.081843000000e-09 6.269048000000e-06 2.085459000000e-09 6.269048000000e-06 2.089564000000e-09 6.269048000000e-06 2.093109000000e-09 6.269047000000e-06 2.096789000000e-09 6.269047000000e-06 2.101106000000e-09 6.269046000000e-06 2.105378000000e-09 6.269045000000e-06 2.110838000000e-09 6.269044000000e-06 2.112251000000e-09 6.269048000000e-06 2.113753000000e-09 6.269039000000e-06 2.118558000000e-09 6.269044000000e-06 2.122133000000e-09 6.269042000000e-06 2.129360000000e-09 6.269041000000e-06 2.132821000000e-09 6.269041000000e-06 2.136929000000e-09 6.269040000000e-06 2.139763000000e-09 6.269040000000e-06 2.142597000000e-09 6.269040000000e-06 2.147012000000e-09 6.269039000000e-06 2.152765000000e-09 6.269038000000e-06 2.154377000000e-09 6.269042000000e-06 2.155442000000e-09 6.269033000000e-06 2.158852000000e-09 6.269038000000e-06 2.162621000000e-09 6.269037000000e-06 2.166944000000e-09 6.269048000000e-06 2.170618000000e-09 6.269032000000e-06 2.174167000000e-09 6.269033000000e-06 2.179170000000e-09 6.269034000000e-06 2.183292000000e-09 6.269034000000e-06 2.188867000000e-09 6.269035000000e-06 2.190278000000e-09 6.269037000000e-06 2.191779000000e-09 6.269031000000e-06 2.196584000000e-09 6.269035000000e-06 2.200169000000e-09 6.269034000000e-06 2.207050000000e-09 6.269033000000e-06 2.210543000000e-09 6.269033000000e-06 2.214570000000e-09 6.269033000000e-06 2.217383000000e-09 6.269032000000e-06 2.220196000000e-09 6.269032000000e-06 2.224548000000e-09 6.269032000000e-06 2.230327000000e-09 6.269031000000e-06 2.231668000000e-09 6.269034000000e-06 2.232487000000e-09 6.269029000000e-06 2.235108000000e-09 6.269031000000e-06 2.238430000000e-09 6.269031000000e-06 2.242101000000e-09 6.269031000000e-06 2.245250000000e-09 6.269031000000e-06 2.248623000000e-09 6.269030000000e-06 2.252399000000e-09 6.269030000000e-06 2.256336000000e-09 6.269030000000e-06 2.261919000000e-09 6.269029000000e-06 2.264384000000e-09 6.269031000000e-06 2.265883000000e-09 6.269030000000e-06 2.270679000000e-09 6.269025000000e-06 2.277378000000e-09 6.269031000000e-06 2.283984000000e-09 6.269028000000e-06 2.291963000000e-09 6.269028000000e-06 2.303337000000e-09 6.269027000000e-06 2.323042000000e-09 6.269027000000e-06 2.352076000000e-09 6.269026000000e-06 2.407975000000e-09 6.269024000000e-06 2.543499000000e-09 6.269021000000e-06 2.778736000000e-09 6.269019000000e-06 3.128736000000e-09 6.269018000000e-06 3.478736000000e-09 6.269018000000e-06 3.828736000000e-09 6.269018000000e-06 4.076000000000e-09 6.269018000000e-06 4.076500000000e-09 2.038905000000e-02 4.077000000000e-09 4.008577000000e-02 4.077306000000e-09 3.906386000000e-02 4.077515000000e-09 3.826670000000e-02 4.078112000000e-09 3.572769000000e-02 4.079900000000e-09 2.851080000000e-02 4.082540000000e-09 1.954769000000e-02 4.086501000000e-09 1.039432000000e-02 4.092049000000e-09 3.780495000000e-03 4.100074000000e-09 6.746006000000e-04 4.112222000000e-09 -3.134023000000e-05 4.128358000000e-09 2.199821000000e-05 4.151784000000e-09 -4.195345000000e-06 4.181738000000e-09 1.635145000000e-05 4.223091000000e-09 -1.027531000000e-06 4.287381000000e-09 1.497469000000e-05 4.412795000000e-09 -6.570495000000e-07 4.639879000000e-09 1.494960000000e-05 4.989879000000e-09 -1.075727000000e-06 5.339879000000e-09 1.531098000000e-05 5.689879000000e-09 -1.377229000000e-06 6.039879000000e-09 1.560397000000e-05 6.389879000000e-09 -1.678752000000e-06 6.739879000000e-09 1.585947000000e-05 7.000000000000e-09 -1.968867000000e-06)
V_XOR_04 xor_04 0 PWL(0.000000000000e+00 6.995221000000e-06 1.000000000000e-12 6.997984000000e-06 2.000000000000e-12 7.000502000000e-06 5.200000000000e-12 7.006871000000e-06 1.544000000000e-11 7.014253000000e-06 4.820800000000e-11 7.014547000000e-06 1.530656000000e-10 7.014629000000e-06 4.886099000000e-10 7.014537000000e-06 8.386099000000e-10 7.014631000000e-06 9.995000000000e-10 7.014537000000e-06 9.996500000000e-10 7.014551000000e-06 1.000130000000e-09 7.014559000000e-06 1.000271000000e-09 7.014558000000e-06 1.000500000000e-09 7.014537000000e-06 1.000549000000e-09 7.014529000000e-06 1.000579000000e-09 7.014524000000e-06 1.000674000000e-09 7.014504000000e-06 1.000921000000e-09 7.014478000000e-06 1.001177000000e-09 7.014518000000e-06 1.001636000000e-09 7.014605000000e-06 1.002995000000e-09 7.014626000000e-06 1.004717000000e-09 7.014545000000e-06 1.007157000000e-09 7.014563000000e-06 1.009530000000e-09 7.014588000000e-06 1.012064000000e-09 7.014599000000e-06 1.014479000000e-09 7.014598000000e-06 1.016999000000e-09 7.014606000000e-06 1.019780000000e-09 7.014632000000e-06 1.023006000000e-09 7.014800000000e-06 1.025715000000e-09 7.014114000000e-06 1.028767000000e-09 7.013204000000e-06 1.031545000000e-09 7.013311000000e-06 1.034548000000e-09 7.016796000000e-06 1.037295000000e-09 7.024178000000e-06 1.040188000000e-09 7.051391000000e-06 1.042931000000e-09 7.012257000000e-06 1.046095000000e-09 6.857705000000e-06 1.049020000000e-09 6.665026000000e-06 1.051920000000e-09 6.766317000000e-06 1.055268000000e-09 8.323577000000e-06 1.057963000000e-09 1.259121000000e-05 1.059420000000e-09 1.296154000000e-05 1.060877000000e-09 1.197167000000e-05 1.063981000000e-09 -7.869854000000e-06 1.066813000000e-09 -5.319995000000e-05 1.069715000000e-09 -9.570616000000e-05 1.073141000000e-09 9.929032000000e-05 1.075000000000e-09 5.034343000000e-04 1.075500000000e-09 -1.983850000000e-02 1.075834000000e-09 -3.323126000000e-02 1.076000000000e-09 -3.971040000000e-02 1.076266000000e-09 -3.831214000000e-02 1.076419000000e-09 -3.742570000000e-02 1.076822000000e-09 -3.483245000000e-02 1.078112000000e-09 -2.714303000000e-02 1.079915000000e-09 -1.869766000000e-02 1.082834000000e-09 -1.073239000000e-02 1.086452000000e-09 -9.917346000000e-03 1.089863000000e-09 -1.733105000000e-02 1.094093000000e-09 -2.443177000000e-02 1.097558000000e-09 -8.030776000000e-04 1.101264000000e-09 7.716587000000e-02 1.105520000000e-09 1.940637000000e-01 1.109056000000e-09 2.781330000000e-01 1.112992000000e-09 3.612838000000e-01 1.115807000000e-09 4.245501000000e-01 1.118621000000e-09 4.910017000000e-01 1.121942000000e-09 5.677712000000e-01 1.125724000000e-09 6.406370000000e-01 1.129501000000e-09 6.941624000000e-01 1.133249000000e-09 7.313310000000e-01 1.135809000000e-09 7.507989000000e-01 1.138369000000e-09 7.654659000000e-01 1.141791000000e-09 7.828464000000e-01 1.145734000000e-09 8.008694000000e-01 1.150017000000e-09 8.172255000000e-01 1.153865000000e-09 8.284260000000e-01 1.158361000000e-09 8.377433000000e-01 1.161824000000e-09 8.425064000000e-01 1.165535000000e-09 8.462194000000e-01 1.169527000000e-09 8.492584000000e-01 1.173109000000e-09 8.513710000000e-01 1.177056000000e-09 8.530824000000e-01 1.179535000000e-09 8.539098000000e-01 1.182013000000e-09 8.545463000000e-01 1.185429000000e-09 8.552868000000e-01 1.189651000000e-09 8.561614000000e-01 1.193349000000e-09 8.568377000000e-01 1.197208000000e-09 8.574387000000e-01 1.200595000000e-09 8.578843000000e-01 1.204042000000e-09 8.583270000000e-01 1.207661000000e-09 8.587506000000e-01 1.212044000000e-09 8.591459000000e-01 1.215603000000e-09 8.593598000000e-01 1.219624000000e-09 8.594873000000e-01 1.222280000000e-09 8.594078000000e-01 1.224935000000e-09 8.591981000000e-01 1.228316000000e-09 8.587334000000e-01 1.229186000000e-09 8.586008000000e-01 1.230042000000e-09 8.584634000000e-01 1.232779000000e-09 8.578893000000e-01 1.235670000000e-09 8.568730000000e-01 1.238863000000e-09 8.554394000000e-01 1.243639000000e-09 8.594518000000e-01 1.246999000000e-09 8.704986000000e-01 1.250850000000e-09 8.887367000000e-01 1.255187000000e-09 9.066353000000e-01 1.258822000000e-09 9.024411000000e-01 1.259631000000e-09 8.952300000000e-01 1.260438000000e-09 8.863590000000e-01 1.263021000000e-09 8.359959000000e-01 1.265957000000e-09 7.420878000000e-01 1.269137000000e-09 6.121730000000e-01 1.273131000000e-09 4.371208000000e-01 1.276658000000e-09 3.023488000000e-01 1.280195000000e-09 1.952351000000e-01 1.284359000000e-09 1.117724000000e-01 1.288216000000e-09 6.860440000000e-02 1.291735000000e-09 4.621820000000e-02 1.292574000000e-09 4.275694000000e-02 1.293423000000e-09 3.948972000000e-02 1.296139000000e-09 3.151122000000e-02 1.299136000000e-09 2.575774000000e-02 1.302736000000e-09 2.061662000000e-02 1.306959000000e-09 1.528028000000e-02 1.310392000000e-09 1.129211000000e-02 1.314112000000e-09 7.774951000000e-03 1.317424000000e-09 5.403071000000e-03 1.320972000000e-09 3.600730000000e-03 1.324632000000e-09 2.377177000000e-03 1.327145000000e-09 1.784601000000e-03 1.329658000000e-09 1.393617000000e-03 1.333049000000e-09 1.020242000000e-03 1.337028000000e-09 7.490126000000e-04 1.341293000000e-09 5.853331000000e-04 1.345153000000e-09 5.205193000000e-04 1.349994000000e-09 5.411348000000e-04 1.353616000000e-09 6.170329000000e-04 1.357116000000e-09 7.057989000000e-04 1.357983000000e-09 7.285721000000e-04 1.358962000000e-09 7.540381000000e-04 1.362092000000e-09 8.329191000000e-04 1.364885000000e-09 8.916523000000e-04 1.369987000000e-09 9.425009000000e-04 1.373500000000e-09 9.281116000000e-04 1.377230000000e-09 8.744837000000e-04 1.381288000000e-09 7.882765000000e-04 1.384815000000e-09 7.015602000000e-04 1.388662000000e-09 6.049247000000e-04 1.389532000000e-09 5.835488000000e-04 1.390483000000e-09 5.603737000000e-04 1.393528000000e-09 4.895018000000e-04 1.396267000000e-09 4.305829000000e-04 1.399530000000e-09 3.670292000000e-04 1.403009000000e-09 3.075350000000e-04 1.406745000000e-09 2.527947000000e-04 1.410579000000e-09 2.057275000000e-04 1.413057000000e-09 1.795755000000e-04 1.415535000000e-09 1.567802000000e-04 1.418933000000e-09 1.299623000000e-04 1.419781000000e-09 1.241503000000e-04 1.420563000000e-09 1.189088000000e-04 1.423064000000e-09 1.035641000000e-04 1.426220000000e-09 8.701874000000e-05 1.429627000000e-09 7.220093000000e-05 1.432942000000e-09 6.032744000000e-05 1.436511000000e-09 4.987154000000e-05 1.439973000000e-09 4.163384000000e-05 1.444113000000e-09 3.376355000000e-05 1.447667000000e-09 2.840918000000e-05 1.448597000000e-09 2.722472000000e-05 1.449278000000e-09 2.637417000000e-05 1.451458000000e-09 2.387186000000e-05 1.454984000000e-09 2.045355000000e-05 1.458241000000e-09 1.788639000000e-05 1.461761000000e-09 1.562700000000e-05 1.465886000000e-09 1.352602000000e-05 1.469389000000e-09 1.211663000000e-05 1.472794000000e-09 1.100727000000e-05 1.475276000000e-09 1.032482000000e-05 1.477758000000e-09 9.748752000000e-06 1.479095000000e-09 9.482951000000e-06 1.479882000000e-09 9.330148000000e-06 1.482402000000e-09 8.887238000000e-06 1.485321000000e-09 8.452398000000e-06 1.488790000000e-09 8.026579000000e-06 1.492381000000e-09 7.671674000000e-06 1.496661000000e-09 7.338761000000e-06 1.500576000000e-09 7.102477000000e-06 1.504103000000e-09 6.933390000000e-06 1.508121000000e-09 6.780429000000e-06 1.509046000000e-09 6.751190000000e-06 1.509764000000e-09 6.728996000000e-06 1.512062000000e-09 6.664103000000e-06 1.514727000000e-09 6.599407000000e-06 1.518391000000e-09 6.525956000000e-06 1.521668000000e-09 6.472955000000e-06 1.525243000000e-09 6.426079000000e-06 1.529365000000e-09 6.383358000000e-06 1.532875000000e-09 6.354647000000e-06 1.534025000000e-09 6.346546000000e-06 1.534117000000e-09 -1.334345000000e-03 1.534180000000e-09 -2.241628000000e-03 1.534382000000e-09 -4.853225000000e-03 1.534737000000e-09 -8.569090000000e-03 1.535025000000e-09 -1.069737000000e-02 1.535086000000e-09 -1.023662000000e-02 1.535120000000e-09 -9.976001000000e-03 1.535227000000e-09 -9.181546000000e-03 1.535516000000e-09 -7.270563000000e-03 1.535770000000e-09 -5.872528000000e-03 1.536253000000e-09 -3.758832000000e-03 1.537797000000e-09 2.292728000000e-04 1.540037000000e-09 2.428735000000e-03 1.542991000000e-09 2.671007000000e-03 1.546340000000e-09 1.529419000000e-03 1.549563000000e-09 5.587918000000e-04 1.553023000000e-09 -8.549481000000e-05 1.556674000000e-09 -3.334817000000e-04 1.561332000000e-09 -2.896417000000e-04 1.564959000000e-09 -1.784154000000e-04 1.568637000000e-09 -9.940521000000e-05 1.572862000000e-09 -4.713092000000e-05 1.576410000000e-09 -2.368759000000e-05 1.580380000000e-09 -7.872395000000e-06 1.584817000000e-09 -2.044900000000e-06 1.588226000000e-09 3.474736000000e-06 1.592181000000e-09 3.170373000000e-06 1.595925000000e-09 6.501401000000e-06 1.599741000000e-09 4.716488000000e-06 1.604581000000e-09 7.406380000000e-06 1.606342000000e-09 6.706423000000e-06 1.608103000000e-09 5.111035000000e-06 1.611836000000e-09 7.601723000000e-06 1.616035000000e-09 5.158202000000e-06 1.619218000000e-09 7.673066000000e-06 1.623182000000e-09 5.124166000000e-06 1.626358000000e-09 7.707584000000e-06 1.629985000000e-09 5.079389000000e-06 1.634074000000e-09 7.724335000000e-06 1.638238000000e-09 5.032840000000e-06 1.643068000000e-09 7.750235000000e-06 1.648476000000e-09 4.961079000000e-06 1.653917000000e-09 7.739928000000e-06 1.658595000000e-09 4.924873000000e-06 1.665047000000e-09 7.745686000000e-06 1.668427000000e-09 4.900212000000e-06 1.674362000000e-09 7.766601000000e-06 1.678501000000e-09 4.878665000000e-06 1.684581000000e-09 7.775540000000e-06 1.686093000000e-09 6.300684000000e-06 1.687486000000e-09 6.320527000000e-06 1.691945000000e-09 6.285914000000e-06 1.695547000000e-09 6.288597000000e-06 1.700342000000e-09 6.271383000000e-06 1.704014000000e-09 6.279526000000e-06 1.707642000000e-09 6.268226000000e-06 1.712914000000e-09 6.276607000000e-06 1.717024000000e-09 6.266979000000e-06 1.722796000000e-09 6.275307000000e-06 1.724262000000e-09 6.271062000000e-06 1.725743000000e-09 6.270672000000e-06 1.730482000000e-09 6.270693000000e-06 1.734128000000e-09 6.270350000000e-06 1.739613000000e-09 6.270402000000e-06 1.743241000000e-09 6.270089000000e-06 1.746998000000e-09 6.270219000000e-06 1.752400000000e-09 6.269883000000e-06 1.756586000000e-09 6.270013000000e-06 1.762468000000e-09 6.269719000000e-06 1.764025000000e-09 6.269820000000e-06 1.765380000000e-09 6.269768000000e-06 1.769719000000e-09 6.269710000000e-06 1.773264000000e-09 6.269681000000e-06 1.778028000000e-09 6.269631000000e-06 1.781718000000e-09 6.269598000000e-06 1.785310000000e-09 6.269560000000e-06 1.790811000000e-09 6.269516000000e-06 1.794844000000e-09 6.269485000000e-06 1.800637000000e-09 6.269457000000e-06 1.802097000000e-09 6.269459000000e-06 1.803580000000e-09 6.269422000000e-06 1.808326000000e-09 6.269390000000e-06 1.811970000000e-09 6.269382000000e-06 1.817496000000e-09 6.269356000000e-06 1.821120000000e-09 6.269330000000e-06 1.824884000000e-09 6.269320000000e-06 1.830308000000e-09 6.269306000000e-06 1.834495000000e-09 6.269291000000e-06 1.840377000000e-09 6.269275000000e-06 1.841939000000e-09 6.269280000000e-06 1.843284000000e-09 6.269257000000e-06 1.847586000000e-09 6.269241000000e-06 1.851115000000e-09 6.269239000000e-06 1.855851000000e-09 6.269227000000e-06 1.859543000000e-09 6.269219000000e-06 1.863125000000e-09 6.269210000000e-06 1.868621000000e-09 6.269198000000e-06 1.872640000000e-09 6.269191000000e-06 1.878406000000e-09 6.269179000000e-06 1.879857000000e-09 6.269186000000e-06 1.881342000000e-09 6.269171000000e-06 1.886097000000e-09 6.269162000000e-06 1.889729000000e-09 6.269162000000e-06 1.895406000000e-09 6.269154000000e-06 1.899019000000e-09 6.269162000000e-06 1.902802000000e-09 6.269140000000e-06 1.908327000000e-09 6.269134000000e-06 1.912510000000e-09 6.269132000000e-06 1.918396000000e-09 6.269125000000e-06 1.923452000000e-09 6.269121000000e-06 1.928319000000e-09 6.269115000000e-06 1.933832000000e-09 6.269111000000e-06 1.937865000000e-09 6.269108000000e-06 1.941516000000e-09 6.269105000000e-06 1.947123000000e-09 6.269100000000e-06 1.951206000000e-09 6.269098000000e-06 1.957151000000e-09 6.269093000000e-06 1.962202000000e-09 6.269091000000e-06 1.967100000000e-09 6.269087000000e-06 1.968013000000e-09 6.269092000000e-06 1.969099000000e-09 6.269083000000e-06 1.972453000000e-09 6.269084000000e-06 1.975701000000e-09 6.269082000000e-06 1.979195000000e-09 6.269081000000e-06 1.983866000000e-09 6.269078000000e-06 1.987814000000e-09 6.269077000000e-06 1.993099000000e-09 6.269082000000e-06 1.998488000000e-09 6.269061000000e-06 2.003935000000e-09 6.269072000000e-06 2.004866000000e-09 6.269076000000e-06 2.005730000000e-09 6.269069000000e-06 2.008495000000e-09 6.269068000000e-06 2.013208000000e-09 6.269066000000e-06 2.016501000000e-09 6.269065000000e-06 2.021215000000e-09 6.269063000000e-06 2.025252000000e-09 6.269062000000e-06 2.030301000000e-09 6.269060000000e-06 2.035760000000e-09 6.269058000000e-06 2.040977000000e-09 6.269057000000e-06 2.042009000000e-09 6.269060000000e-06 2.042812000000e-09 6.269054000000e-06 2.045379000000e-09 6.269055000000e-06 2.049639000000e-09 6.269054000000e-06 2.053254000000e-09 6.269053000000e-06 2.056728000000e-09 6.269053000000e-06 2.062152000000e-09 6.269051000000e-06 2.066039000000e-09 6.269050000000e-06 2.071558000000e-09 6.269049000000e-06 2.076872000000e-09 6.269048000000e-06 2.078300000000e-09 6.269053000000e-06 2.079144000000e-09 6.269042000000e-06 2.081843000000e-09 6.269046000000e-06 2.085459000000e-09 6.269046000000e-06 2.089564000000e-09 6.269046000000e-06 2.093109000000e-09 6.269045000000e-06 2.096789000000e-09 6.269044000000e-06 2.101106000000e-09 6.269043000000e-06 2.105378000000e-09 6.269043000000e-06 2.110838000000e-09 6.269042000000e-06 2.112251000000e-09 6.269046000000e-06 2.113753000000e-09 6.269036000000e-06 2.118558000000e-09 6.269041000000e-06 2.122133000000e-09 6.269040000000e-06 2.129360000000e-09 6.269039000000e-06 2.132821000000e-09 6.269039000000e-06 2.136929000000e-09 6.269038000000e-06 2.139763000000e-09 6.269038000000e-06 2.142597000000e-09 6.269037000000e-06 2.147012000000e-09 6.269037000000e-06 2.152765000000e-09 6.269036000000e-06 2.154377000000e-09 6.269040000000e-06 2.155442000000e-09 6.269031000000e-06 2.158852000000e-09 6.269035000000e-06 2.162621000000e-09 6.269035000000e-06 2.166944000000e-09 6.269045000000e-06 2.170618000000e-09 6.269030000000e-06 2.174167000000e-09 6.269031000000e-06 2.179170000000e-09 6.269032000000e-06 2.183292000000e-09 6.269032000000e-06 2.188867000000e-09 6.269032000000e-06 2.190278000000e-09 6.269035000000e-06 2.191779000000e-09 6.269028000000e-06 2.196584000000e-09 6.269032000000e-06 2.200169000000e-09 6.269031000000e-06 2.207050000000e-09 6.269031000000e-06 2.210543000000e-09 6.269031000000e-06 2.214570000000e-09 6.269030000000e-06 2.217383000000e-09 6.269030000000e-06 2.220196000000e-09 6.269030000000e-06 2.224548000000e-09 6.269030000000e-06 2.230327000000e-09 6.269029000000e-06 2.231668000000e-09 6.269031000000e-06 2.232487000000e-09 6.269027000000e-06 2.235108000000e-09 6.269028000000e-06 2.238430000000e-09 6.269028000000e-06 2.242101000000e-09 6.269028000000e-06 2.245250000000e-09 6.269028000000e-06 2.248623000000e-09 6.269028000000e-06 2.252399000000e-09 6.269028000000e-06 2.256336000000e-09 6.269027000000e-06 2.261919000000e-09 6.269027000000e-06 2.264384000000e-09 6.269029000000e-06 2.265883000000e-09 6.269028000000e-06 2.270679000000e-09 6.269023000000e-06 2.277378000000e-09 6.269029000000e-06 2.283984000000e-09 6.269026000000e-06 2.291963000000e-09 6.269026000000e-06 2.303337000000e-09 6.269025000000e-06 2.323042000000e-09 6.269024000000e-06 2.352076000000e-09 6.269023000000e-06 2.407975000000e-09 6.269022000000e-06 2.543499000000e-09 6.269019000000e-06 2.778736000000e-09 6.269017000000e-06 3.128736000000e-09 6.269016000000e-06 3.478736000000e-09 6.269016000000e-06 3.828736000000e-09 6.269015000000e-06 4.076000000000e-09 6.269016000000e-06 4.076500000000e-09 2.038905000000e-02 4.077000000000e-09 4.008577000000e-02 4.077306000000e-09 3.906386000000e-02 4.077515000000e-09 3.826670000000e-02 4.078112000000e-09 3.572769000000e-02 4.079900000000e-09 2.851080000000e-02 4.082540000000e-09 1.954769000000e-02 4.086501000000e-09 1.039432000000e-02 4.092049000000e-09 3.780496000000e-03 4.100074000000e-09 6.746006000000e-04 4.112222000000e-09 -3.134022000000e-05 4.128358000000e-09 2.199822000000e-05 4.151784000000e-09 -4.195378000000e-06 4.181738000000e-09 1.635147000000e-05 4.223091000000e-09 -1.027578000000e-06 4.287381000000e-09 1.497471000000e-05 4.412795000000e-09 -6.570987000000e-07 4.639879000000e-09 1.494962000000e-05 4.989879000000e-09 -1.075778000000e-06 5.339879000000e-09 1.531100000000e-05 5.689879000000e-09 -1.377278000000e-06 6.039879000000e-09 1.560399000000e-05 6.389879000000e-09 -1.678801000000e-06 6.739879000000e-09 1.585949000000e-05 7.000000000000e-09 -1.968915000000e-06)
V_XOR_05 xor_05 0 PWL(0.000000000000e+00 6.995221000000e-06 1.000000000000e-12 6.997984000000e-06 2.000000000000e-12 7.000502000000e-06 5.200000000000e-12 7.006871000000e-06 1.544000000000e-11 7.014253000000e-06 4.820800000000e-11 7.014547000000e-06 1.530656000000e-10 7.014629000000e-06 4.886099000000e-10 7.014537000000e-06 8.386099000000e-10 7.014631000000e-06 9.995000000000e-10 7.014537000000e-06 9.996500000000e-10 7.014541000000e-06 1.000130000000e-09 7.014550000000e-06 1.000271000000e-09 7.014553000000e-06 1.000500000000e-09 7.014556000000e-06 1.000549000000e-09 7.014556000000e-06 1.000579000000e-09 7.014556000000e-06 1.000674000000e-09 7.014557000000e-06 1.000921000000e-09 7.014559000000e-06 1.001177000000e-09 7.014563000000e-06 1.001636000000e-09 7.014569000000e-06 1.002995000000e-09 7.014574000000e-06 1.004717000000e-09 7.014577000000e-06 1.007157000000e-09 7.014583000000e-06 1.009530000000e-09 7.014586000000e-06 1.012064000000e-09 7.014586000000e-06 1.014479000000e-09 7.014587000000e-06 1.016999000000e-09 7.014587000000e-06 1.019780000000e-09 7.014587000000e-06 1.023006000000e-09 7.014588000000e-06 1.025715000000e-09 7.014577000000e-06 1.028767000000e-09 7.014580000000e-06 1.031545000000e-09 7.014593000000e-06 1.034548000000e-09 7.014623000000e-06 1.037295000000e-09 7.014648000000e-06 1.040188000000e-09 7.014820000000e-06 1.042931000000e-09 7.013965000000e-06 1.046095000000e-09 7.013235000000e-06 1.049020000000e-09 7.013540000000e-06 1.051920000000e-09 7.017253000000e-06 1.055268000000e-09 7.029338000000e-06 1.057963000000e-09 7.053342000000e-06 1.059420000000e-09 7.029336000000e-06 1.060877000000e-09 6.979365000000e-06 1.063981000000e-09 6.800820000000e-06 1.066813000000e-09 6.634908000000e-06 1.069715000000e-09 6.898967000000e-06 1.073141000000e-09 9.444503000000e-06 1.075000000000e-09 1.291847000000e-05 1.075500000000e-09 -2.045179000000e-02 1.075834000000e-09 -3.391185000000e-02 1.076000000000e-09 -4.042314000000e-02 1.076266000000e-09 -3.910000000000e-02 1.076419000000e-09 -3.825871000000e-02 1.076822000000e-09 -3.579815000000e-02 1.078112000000e-09 -2.859044000000e-02 1.079915000000e-09 -2.076505000000e-02 1.082834000000e-09 -1.255002000000e-02 1.086452000000e-09 -6.798617000000e-03 1.089863000000e-09 -3.925246000000e-03 1.094093000000e-09 -1.870847000000e-03 1.097558000000e-09 -5.099396000000e-04 1.101264000000e-09 6.621446000000e-04 1.105520000000e-09 -8.543673000000e-04 1.109056000000e-09 -7.176278000000e-03 1.112992000000e-09 -1.985340000000e-02 1.115807000000e-09 -1.343999000000e-02 1.118621000000e-09 5.877160000000e-03 1.121942000000e-09 7.006050000000e-02 1.125724000000e-09 1.719747000000e-01 1.129501000000e-09 2.646895000000e-01 1.133249000000e-09 3.438026000000e-01 1.135809000000e-09 4.005892000000e-01 1.138369000000e-09 4.596145000000e-01 1.141791000000e-09 5.405114000000e-01 1.145734000000e-09 6.218187000000e-01 1.150017000000e-09 6.872713000000e-01 1.153865000000e-09 7.273316000000e-01 1.158361000000e-09 7.591746000000e-01 1.161824000000e-09 7.777222000000e-01 1.165535000000e-09 7.954374000000e-01 1.169527000000e-09 8.118888000000e-01 1.173109000000e-09 8.236395000000e-01 1.177056000000e-09 8.333952000000e-01 1.179535000000e-09 8.380384000000e-01 1.182013000000e-09 8.415376000000e-01 1.185429000000e-09 8.452058000000e-01 1.189651000000e-09 8.486710000000e-01 1.193349000000e-09 8.509691000000e-01 1.197208000000e-09 8.527786000000e-01 1.200595000000e-09 8.539030000000e-01 1.204042000000e-09 8.547764000000e-01 1.207661000000e-09 8.555530000000e-01 1.212044000000e-09 8.564426000000e-01 1.215603000000e-09 8.570514000000e-01 1.219624000000e-09 8.576492000000e-01 1.222280000000e-09 8.579860000000e-01 1.224935000000e-09 8.582766000000e-01 1.228316000000e-09 8.586202000000e-01 1.229186000000e-09 8.586930000000e-01 1.230042000000e-09 8.587661000000e-01 1.232779000000e-09 8.589796000000e-01 1.235670000000e-09 8.591666000000e-01 1.238863000000e-09 8.593408000000e-01 1.243639000000e-09 8.595974000000e-01 1.246999000000e-09 8.597663000000e-01 1.250850000000e-09 8.598896000000e-01 1.255187000000e-09 8.599514000000e-01 1.258822000000e-09 8.599058000000e-01 1.259631000000e-09 8.598671000000e-01 1.260438000000e-09 8.598173000000e-01 1.263021000000e-09 8.595590000000e-01 1.265957000000e-09 8.591263000000e-01 1.269137000000e-09 8.585783000000e-01 1.273131000000e-09 8.575129000000e-01 1.276658000000e-09 8.559097000000e-01 1.280195000000e-09 8.559746000000e-01 1.284359000000e-09 8.647032000000e-01 1.288216000000e-09 8.815473000000e-01 1.291735000000e-09 8.985767000000e-01 1.292574000000e-09 9.021026000000e-01 1.293423000000e-09 9.054228000000e-01 1.296139000000e-09 9.094128000000e-01 1.299136000000e-09 8.899538000000e-01 1.302736000000e-09 8.133116000000e-01 1.306959000000e-09 6.585332000000e-01 1.310392000000e-09 5.068204000000e-01 1.314112000000e-09 3.531509000000e-01 1.317424000000e-09 2.411233000000e-01 1.320972000000e-09 1.509913000000e-01 1.324632000000e-09 9.304385000000e-02 1.327145000000e-09 6.644554000000e-02 1.329658000000e-09 5.058837000000e-02 1.333049000000e-09 3.641950000000e-02 1.337028000000e-09 2.701355000000e-02 1.341293000000e-09 2.079598000000e-02 1.345153000000e-09 1.601351000000e-02 1.349994000000e-09 1.050349000000e-02 1.353616000000e-09 7.222331000000e-03 1.357116000000e-09 4.898040000000e-03 1.357983000000e-09 4.458572000000e-03 1.358962000000e-09 3.990776000000e-03 1.362092000000e-09 2.797718000000e-03 1.364885000000e-09 2.059275000000e-03 1.369987000000e-09 1.219571000000e-03 1.373500000000e-09 8.989171000000e-04 1.377230000000e-09 6.890362000000e-04 1.381288000000e-09 5.609865000000e-04 1.384815000000e-09 5.171191000000e-04 1.388662000000e-09 5.404805000000e-04 1.389532000000e-09 5.560498000000e-04 1.390483000000e-09 5.746164000000e-04 1.393528000000e-09 6.442974000000e-04 1.396267000000e-09 7.142305000000e-04 1.399530000000e-09 7.992744000000e-04 1.403009000000e-09 8.791863000000e-04 1.406745000000e-09 9.327563000000e-04 1.410579000000e-09 9.403610000000e-04 1.413057000000e-09 9.220575000000e-04 1.415535000000e-09 8.855205000000e-04 1.418933000000e-09 8.169029000000e-04 1.419781000000e-09 7.968495000000e-04 1.420563000000e-09 7.781580000000e-04 1.423064000000e-09 7.165067000000e-04 1.426220000000e-09 6.372034000000e-04 1.429627000000e-09 5.536392000000e-04 1.432942000000e-09 4.773656000000e-04 1.436511000000e-09 4.028631000000e-04 1.439973000000e-09 3.389935000000e-04 1.444113000000e-09 2.735859000000e-04 1.447667000000e-09 2.264021000000e-04 1.448597000000e-09 2.155949000000e-04 1.449278000000e-09 2.078069000000e-04 1.451458000000e-09 1.845948000000e-04 1.454984000000e-09 1.521132000000e-04 1.458241000000e-09 1.270809000000e-04 1.461761000000e-09 1.045916000000e-04 1.465886000000e-09 8.329622000000e-05 1.469389000000e-09 6.878297000000e-05 1.472794000000e-09 5.723455000000e-05 1.475276000000e-09 5.008567000000e-05 1.477758000000e-09 4.400650000000e-05 1.479095000000e-09 4.118671000000e-05 1.479882000000e-09 3.956456000000e-05 1.482402000000e-09 3.484951000000e-05 1.485321000000e-09 3.020399000000e-05 1.488790000000e-09 2.563976000000e-05 1.492381000000e-09 2.182219000000e-05 1.496661000000e-09 1.823018000000e-05 1.500576000000e-09 1.567397000000e-05 1.504103000000e-09 1.384154000000e-05 1.508121000000e-09 1.218170000000e-05 1.509046000000e-09 1.186402000000e-05 1.509764000000e-09 1.162287000000e-05 1.512062000000e-09 1.091694000000e-05 1.514727000000e-09 1.021297000000e-05 1.518391000000e-09 9.413900000000e-06 1.521668000000e-09 8.836779000000e-06 1.525243000000e-09 8.326141000000e-06 1.529365000000e-09 7.860657000000e-06 1.532875000000e-09 7.547702000000e-06 1.534025000000e-09 7.459419000000e-06 1.534117000000e-09 -1.333294000000e-03 1.534180000000e-09 -2.240582000000e-03 1.534382000000e-09 -4.852203000000e-03 1.534737000000e-09 -8.568130000000e-03 1.535025000000e-09 -1.069644000000e-02 1.535086000000e-09 -1.023570000000e-02 1.535120000000e-09 -9.975084000000e-03 1.535227000000e-09 -9.180637000000e-03 1.535516000000e-09 -7.269668000000e-03 1.535770000000e-09 -5.871630000000e-03 1.536253000000e-09 -3.757905000000e-03 1.537797000000e-09 2.302812000000e-04 1.540037000000e-09 2.429841000000e-03 1.542991000000e-09 2.672044000000e-03 1.546340000000e-09 1.530306000000e-03 1.549563000000e-09 5.593722000000e-04 1.553023000000e-09 -8.519732000000e-05 1.556674000000e-09 -3.333383000000e-04 1.561332000000e-09 -2.895690000000e-04 1.564959000000e-09 -1.783713000000e-04 1.568637000000e-09 -9.937824000000e-05 1.572862000000e-09 -4.711688000000e-05 1.576410000000e-09 -2.367896000000e-05 1.580380000000e-09 -7.868019000000e-06 1.584817000000e-09 -2.042032000000e-06 1.588226000000e-09 3.475746000000e-06 1.592181000000e-09 3.171616000000e-06 1.595925000000e-09 6.501505000000e-06 1.599741000000e-09 4.717172000000e-06 1.604581000000e-09 7.406173000000e-06 1.606342000000e-09 6.706376000000e-06 1.608103000000e-09 5.111406000000e-06 1.611836000000e-09 7.601409000000e-06 1.616035000000e-09 5.158629000000e-06 1.619218000000e-09 7.672827000000e-06 1.623182000000e-09 5.124540000000e-06 1.626358000000e-09 7.707316000000e-06 1.629985000000e-09 5.079711000000e-06 1.634074000000e-09 7.724152000000e-06 1.638238000000e-09 5.032971000000e-06 1.643068000000e-09 7.750054000000e-06 1.648476000000e-09 4.961328000000e-06 1.653917000000e-09 7.739636000000e-06 1.658595000000e-09 4.925133000000e-06 1.665047000000e-09 7.745410000000e-06 1.668427000000e-09 4.900460000000e-06 1.674362000000e-09 7.766344000000e-06 1.678501000000e-09 4.878903000000e-06 1.684581000000e-09 7.775293000000e-06 1.686093000000e-09 6.300673000000e-06 1.687486000000e-09 6.320521000000e-06 1.691945000000e-09 6.285902000000e-06 1.695547000000e-09 6.288595000000e-06 1.700342000000e-09 6.271374000000e-06 1.704014000000e-09 6.279526000000e-06 1.707642000000e-09 6.268218000000e-06 1.712914000000e-09 6.276606000000e-06 1.717024000000e-09 6.266970000000e-06 1.722796000000e-09 6.275306000000e-06 1.724262000000e-09 6.271058000000e-06 1.725743000000e-09 6.270668000000e-06 1.730482000000e-09 6.270689000000e-06 1.734128000000e-09 6.270345000000e-06 1.739613000000e-09 6.270398000000e-06 1.743241000000e-09 6.270085000000e-06 1.746998000000e-09 6.270215000000e-06 1.752400000000e-09 6.269879000000e-06 1.756586000000e-09 6.270009000000e-06 1.762468000000e-09 6.269714000000e-06 1.764025000000e-09 6.269816000000e-06 1.765380000000e-09 6.269764000000e-06 1.769719000000e-09 6.269705000000e-06 1.773264000000e-09 6.269677000000e-06 1.778028000000e-09 6.269627000000e-06 1.781718000000e-09 6.269593000000e-06 1.785310000000e-09 6.269556000000e-06 1.790811000000e-09 6.269512000000e-06 1.794844000000e-09 6.269481000000e-06 1.800637000000e-09 6.269452000000e-06 1.802097000000e-09 6.269454000000e-06 1.803580000000e-09 6.269418000000e-06 1.808326000000e-09 6.269385000000e-06 1.811970000000e-09 6.269378000000e-06 1.817496000000e-09 6.269352000000e-06 1.821120000000e-09 6.269326000000e-06 1.824884000000e-09 6.269316000000e-06 1.830308000000e-09 6.269302000000e-06 1.834495000000e-09 6.269287000000e-06 1.840377000000e-09 6.269271000000e-06 1.841939000000e-09 6.269276000000e-06 1.843284000000e-09 6.269253000000e-06 1.847586000000e-09 6.269236000000e-06 1.851115000000e-09 6.269234000000e-06 1.855851000000e-09 6.269223000000e-06 1.859543000000e-09 6.269214000000e-06 1.863125000000e-09 6.269206000000e-06 1.868621000000e-09 6.269193000000e-06 1.872640000000e-09 6.269186000000e-06 1.878406000000e-09 6.269175000000e-06 1.879857000000e-09 6.269181000000e-06 1.881342000000e-09 6.269167000000e-06 1.886097000000e-09 6.269158000000e-06 1.889729000000e-09 6.269157000000e-06 1.895406000000e-09 6.269149000000e-06 1.899019000000e-09 6.269157000000e-06 1.902802000000e-09 6.269136000000e-06 1.908327000000e-09 6.269130000000e-06 1.912510000000e-09 6.269127000000e-06 1.918396000000e-09 6.269120000000e-06 1.923452000000e-09 6.269117000000e-06 1.928319000000e-09 6.269111000000e-06 1.933832000000e-09 6.269107000000e-06 1.937865000000e-09 6.269103000000e-06 1.941516000000e-09 6.269101000000e-06 1.947123000000e-09 6.269095000000e-06 1.951206000000e-09 6.269094000000e-06 1.957151000000e-09 6.269088000000e-06 1.962202000000e-09 6.269086000000e-06 1.967100000000e-09 6.269082000000e-06 1.968013000000e-09 6.269087000000e-06 1.969099000000e-09 6.269078000000e-06 1.972453000000e-09 6.269079000000e-06 1.975701000000e-09 6.269078000000e-06 1.979195000000e-09 6.269076000000e-06 1.983866000000e-09 6.269074000000e-06 1.987814000000e-09 6.269072000000e-06 1.993099000000e-09 6.269077000000e-06 1.998488000000e-09 6.269057000000e-06 2.003935000000e-09 6.269067000000e-06 2.004866000000e-09 6.269072000000e-06 2.005730000000e-09 6.269064000000e-06 2.008495000000e-09 6.269064000000e-06 2.013208000000e-09 6.269061000000e-06 2.016501000000e-09 6.269060000000e-06 2.021215000000e-09 6.269058000000e-06 2.025252000000e-09 6.269057000000e-06 2.030301000000e-09 6.269055000000e-06 2.035760000000e-09 6.269054000000e-06 2.040977000000e-09 6.269052000000e-06 2.042009000000e-09 6.269056000000e-06 2.042812000000e-09 6.269049000000e-06 2.045379000000e-09 6.269050000000e-06 2.049639000000e-09 6.269049000000e-06 2.053254000000e-09 6.269049000000e-06 2.056728000000e-09 6.269048000000e-06 2.062152000000e-09 6.269047000000e-06 2.066039000000e-09 6.269046000000e-06 2.071558000000e-09 6.269044000000e-06 2.076872000000e-09 6.269043000000e-06 2.078300000000e-09 6.269048000000e-06 2.079144000000e-09 6.269038000000e-06 2.081843000000e-09 6.269041000000e-06 2.085459000000e-09 6.269042000000e-06 2.089564000000e-09 6.269041000000e-06 2.093109000000e-09 6.269040000000e-06 2.096789000000e-09 6.269040000000e-06 2.101106000000e-09 6.269039000000e-06 2.105378000000e-09 6.269038000000e-06 2.110838000000e-09 6.269037000000e-06 2.112251000000e-09 6.269041000000e-06 2.113753000000e-09 6.269032000000e-06 2.118558000000e-09 6.269037000000e-06 2.122133000000e-09 6.269036000000e-06 2.129360000000e-09 6.269035000000e-06 2.132821000000e-09 6.269034000000e-06 2.136929000000e-09 6.269034000000e-06 2.139763000000e-09 6.269033000000e-06 2.142597000000e-09 6.269033000000e-06 2.147012000000e-09 6.269032000000e-06 2.152765000000e-09 6.269031000000e-06 2.154377000000e-09 6.269035000000e-06 2.155442000000e-09 6.269026000000e-06 2.158852000000e-09 6.269031000000e-06 2.162621000000e-09 6.269030000000e-06 2.166944000000e-09 6.269041000000e-06 2.170618000000e-09 6.269026000000e-06 2.174167000000e-09 6.269026000000e-06 2.179170000000e-09 6.269028000000e-06 2.183292000000e-09 6.269027000000e-06 2.188867000000e-09 6.269028000000e-06 2.190278000000e-09 6.269031000000e-06 2.191779000000e-09 6.269024000000e-06 2.196584000000e-09 6.269028000000e-06 2.200169000000e-09 6.269027000000e-06 2.207050000000e-09 6.269026000000e-06 2.210543000000e-09 6.269026000000e-06 2.214570000000e-09 6.269026000000e-06 2.217383000000e-09 6.269025000000e-06 2.220196000000e-09 6.269025000000e-06 2.224548000000e-09 6.269025000000e-06 2.230327000000e-09 6.269025000000e-06 2.231668000000e-09 6.269027000000e-06 2.232487000000e-09 6.269022000000e-06 2.235108000000e-09 6.269024000000e-06 2.238430000000e-09 6.269024000000e-06 2.242101000000e-09 6.269024000000e-06 2.245250000000e-09 6.269024000000e-06 2.248623000000e-09 6.269023000000e-06 2.252399000000e-09 6.269023000000e-06 2.256336000000e-09 6.269023000000e-06 2.261919000000e-09 6.269023000000e-06 2.264384000000e-09 6.269024000000e-06 2.265883000000e-09 6.269023000000e-06 2.270679000000e-09 6.269018000000e-06 2.277378000000e-09 6.269024000000e-06 2.283984000000e-09 6.269021000000e-06 2.291963000000e-09 6.269021000000e-06 2.303337000000e-09 6.269020000000e-06 2.323042000000e-09 6.269020000000e-06 2.352076000000e-09 6.269019000000e-06 2.407975000000e-09 6.269017000000e-06 2.543499000000e-09 6.269015000000e-06 2.778736000000e-09 6.269012000000e-06 3.128736000000e-09 6.269011000000e-06 3.478736000000e-09 6.269011000000e-06 3.828736000000e-09 6.269011000000e-06 4.076000000000e-09 6.269011000000e-06 4.076500000000e-09 2.038904000000e-02 4.077000000000e-09 4.008576000000e-02 4.077306000000e-09 3.906386000000e-02 4.077515000000e-09 3.826670000000e-02 4.078112000000e-09 3.572769000000e-02 4.079900000000e-09 2.851080000000e-02 4.082540000000e-09 1.954769000000e-02 4.086501000000e-09 1.039432000000e-02 4.092049000000e-09 3.780495000000e-03 4.100074000000e-09 6.746005000000e-04 4.112222000000e-09 -3.134022000000e-05 4.128358000000e-09 2.199822000000e-05 4.151784000000e-09 -4.195376000000e-06 4.181738000000e-09 1.635147000000e-05 4.223091000000e-09 -1.027577000000e-06 4.287381000000e-09 1.497471000000e-05 4.412795000000e-09 -6.570979000000e-07 4.639879000000e-09 1.494962000000e-05 4.989879000000e-09 -1.075777000000e-06 5.339879000000e-09 1.531100000000e-05 5.689879000000e-09 -1.377277000000e-06 6.039879000000e-09 1.560398000000e-05 6.389879000000e-09 -1.678800000000e-06 6.739879000000e-09 1.585948000000e-05 7.000000000000e-09 -1.968915000000e-06)
V_XOR_06 xor_06 0 PWL(0.000000000000e+00 6.995221000000e-06 1.000000000000e-12 6.997984000000e-06 2.000000000000e-12 7.000502000000e-06 5.200000000000e-12 7.006871000000e-06 1.544000000000e-11 7.014253000000e-06 4.820800000000e-11 7.014547000000e-06 1.530656000000e-10 7.014629000000e-06 4.886099000000e-10 7.014537000000e-06 8.386099000000e-10 7.014631000000e-06 9.995000000000e-10 7.014537000000e-06 9.996500000000e-10 7.014541000000e-06 1.000130000000e-09 7.014550000000e-06 1.000271000000e-09 7.014553000000e-06 1.000500000000e-09 7.014556000000e-06 1.000549000000e-09 7.014557000000e-06 1.000579000000e-09 7.014557000000e-06 1.000674000000e-09 7.014559000000e-06 1.000921000000e-09 7.014561000000e-06 1.001177000000e-09 7.014564000000e-06 1.001636000000e-09 7.014567000000e-06 1.002995000000e-09 7.014574000000e-06 1.004717000000e-09 7.014578000000e-06 1.007157000000e-09 7.014583000000e-06 1.009530000000e-09 7.014585000000e-06 1.012064000000e-09 7.014586000000e-06 1.014479000000e-09 7.014587000000e-06 1.016999000000e-09 7.014587000000e-06 1.019780000000e-09 7.014587000000e-06 1.023006000000e-09 7.014586000000e-06 1.025715000000e-09 7.014586000000e-06 1.028767000000e-09 7.014586000000e-06 1.031545000000e-09 7.014585000000e-06 1.034548000000e-09 7.014585000000e-06 1.037295000000e-09 7.014585000000e-06 1.040188000000e-09 7.014586000000e-06 1.042931000000e-09 7.014574000000e-06 1.046095000000e-09 7.014582000000e-06 1.049020000000e-09 7.014594000000e-06 1.051920000000e-09 7.014624000000e-06 1.055268000000e-09 7.014673000000e-06 1.057963000000e-09 7.014780000000e-06 1.059420000000e-09 7.014362000000e-06 1.060877000000e-09 7.013610000000e-06 1.063981000000e-09 7.013192000000e-06 1.066813000000e-09 7.013986000000e-06 1.069715000000e-09 7.018948000000e-06 1.073141000000e-09 7.036773000000e-06 1.075000000000e-09 7.055893000000e-06 1.075500000000e-09 -2.045881000000e-02 1.075834000000e-09 -3.391888000000e-02 1.076000000000e-09 -4.043039000000e-02 1.076266000000e-09 -3.910837000000e-02 1.076419000000e-09 -3.826775000000e-02 1.076822000000e-09 -3.580898000000e-02 1.078112000000e-09 -2.860466000000e-02 1.079915000000e-09 -2.077678000000e-02 1.082834000000e-09 -1.253847000000e-02 1.086452000000e-09 -6.732962000000e-03 1.089863000000e-09 -3.811745000000e-03 1.094093000000e-09 -1.919479000000e-03 1.097558000000e-09 -1.159658000000e-03 1.101264000000e-09 -7.039665000000e-04 1.105520000000e-09 -4.603783000000e-04 1.109056000000e-09 -3.675221000000e-04 1.112992000000e-09 -3.178072000000e-04 1.115807000000e-09 -5.273820000000e-05 1.118621000000e-09 4.037018000000e-04 1.121942000000e-09 1.127701000000e-03 1.125724000000e-09 5.322912000000e-04 1.129501000000e-09 -4.844990000000e-03 1.133249000000e-09 -1.607469000000e-02 1.135809000000e-09 -1.603421000000e-02 1.138369000000e-09 -9.736797000000e-03 1.141791000000e-09 3.689963000000e-02 1.145734000000e-09 1.364316000000e-01 1.150017000000e-09 2.468943000000e-01 1.153865000000e-09 3.296791000000e-01 1.158361000000e-09 4.289933000000e-01 1.161824000000e-09 5.112914000000e-01 1.165535000000e-09 5.930407000000e-01 1.169527000000e-09 6.628808000000e-01 1.173109000000e-09 7.077214000000e-01 1.177056000000e-09 7.421814000000e-01 1.179535000000e-09 7.590411000000e-01 1.182013000000e-09 7.722138000000e-01 1.185429000000e-09 7.889656000000e-01 1.189651000000e-09 8.074351000000e-01 1.193349000000e-09 8.205009000000e-01 1.197208000000e-09 8.309334000000e-01 1.200595000000e-09 8.375651000000e-01 1.204042000000e-09 8.423636000000e-01 1.207661000000e-09 8.460240000000e-01 1.212044000000e-09 8.494005000000e-01 1.215603000000e-09 8.514617000000e-01 1.219624000000e-09 8.531876000000e-01 1.222280000000e-09 8.540512000000e-01 1.224935000000e-09 8.546951000000e-01 1.228316000000e-09 8.554290000000e-01 1.229186000000e-09 8.556106000000e-01 1.230042000000e-09 8.557899000000e-01 1.232779000000e-09 8.563387000000e-01 1.235670000000e-09 8.568590000000e-01 1.238863000000e-09 8.573602000000e-01 1.243639000000e-09 8.579923000000e-01 1.246999000000e-09 8.583667000000e-01 1.250850000000e-09 8.587309000000e-01 1.255187000000e-09 8.590630000000e-01 1.258822000000e-09 8.592818000000e-01 1.259631000000e-09 8.593225000000e-01 1.260438000000e-09 8.593619000000e-01 1.263021000000e-09 8.594740000000e-01 1.265957000000e-09 8.595795000000e-01 1.269137000000e-09 8.596722000000e-01 1.273131000000e-09 8.597583000000e-01 1.276658000000e-09 8.598115000000e-01 1.280195000000e-09 8.598777000000e-01 1.284359000000e-09 8.599892000000e-01 1.288216000000e-09 8.600690000000e-01 1.291735000000e-09 8.600876000000e-01 1.292574000000e-09 8.600864000000e-01 1.293423000000e-09 8.600843000000e-01 1.296139000000e-09 8.600541000000e-01 1.299136000000e-09 8.599083000000e-01 1.302736000000e-09 8.594915000000e-01 1.306959000000e-09 8.587961000000e-01 1.310392000000e-09 8.580467000000e-01 1.314112000000e-09 8.565989000000e-01 1.317424000000e-09 8.553798000000e-01 1.320972000000e-09 8.585792000000e-01 1.324632000000e-09 8.704328000000e-01 1.327145000000e-09 8.812099000000e-01 1.329658000000e-09 8.941347000000e-01 1.333049000000e-09 9.075333000000e-01 1.337028000000e-09 8.986597000000e-01 1.341293000000e-09 8.215374000000e-01 1.345153000000e-09 6.854522000000e-01 1.349994000000e-09 4.754017000000e-01 1.353616000000e-09 3.298609000000e-01 1.357116000000e-09 2.171450000000e-01 1.357983000000e-09 1.943182000000e-01 1.358962000000e-09 1.702632000000e-01 1.362092000000e-09 1.117761000000e-01 1.364885000000e-09 7.827891000000e-02 1.369987000000e-09 4.346472000000e-02 1.373500000000e-09 3.198947000000e-02 1.377230000000e-09 2.488019000000e-02 1.381288000000e-09 1.936363000000e-02 1.384815000000e-09 1.500572000000e-02 1.388662000000e-09 1.066720000000e-02 1.389532000000e-09 9.823960000000e-03 1.390483000000e-09 8.934568000000e-03 1.393528000000e-09 6.481863000000e-03 1.396267000000e-09 4.771171000000e-03 1.399530000000e-09 3.284529000000e-03 1.403009000000e-09 2.223274000000e-03 1.406745000000e-09 1.501598000000e-03 1.410579000000e-09 1.047033000000e-03 1.413057000000e-09 8.438621000000e-04 1.415535000000e-09 7.119005000000e-04 1.418933000000e-09 5.896670000000e-04 1.419781000000e-09 5.700777000000e-04 1.420563000000e-09 5.536797000000e-04 1.423064000000e-09 5.211088000000e-04 1.426220000000e-09 5.262746000000e-04 1.429627000000e-09 5.819575000000e-04 1.432942000000e-09 6.607815000000e-04 1.436511000000e-09 7.528746000000e-04 1.439973000000e-09 8.395657000000e-04 1.444113000000e-09 9.169385000000e-04 1.447667000000e-09 9.432806000000e-04 1.448597000000e-09 9.411553000000e-04 1.449278000000e-09 9.388625000000e-04 1.451458000000e-09 9.224128000000e-04 1.454984000000e-09 8.712198000000e-04 1.458241000000e-09 8.040227000000e-04 1.461761000000e-09 7.197725000000e-04 1.465886000000e-09 6.168271000000e-04 1.469389000000e-09 5.319644000000e-04 1.472794000000e-09 4.554060000000e-04 1.475276000000e-09 4.044393000000e-04 1.477758000000e-09 3.575506000000e-04 1.479095000000e-09 3.347459000000e-04 1.479882000000e-09 3.215354000000e-04 1.482402000000e-09 2.821429000000e-04 1.485321000000e-09 2.417724000000e-04 1.488790000000e-09 2.005477000000e-04 1.492381000000e-09 1.648245000000e-04 1.496661000000e-09 1.301381000000e-04 1.500576000000e-09 1.047733000000e-04 1.504103000000e-09 8.623435000000e-05 1.508121000000e-09 6.918635000000e-05 1.509046000000e-09 6.588909000000e-05 1.509764000000e-09 6.338372000000e-05 1.512062000000e-09 5.602672000000e-05 1.514727000000e-09 4.864624000000e-05 1.518391000000e-09 4.021464000000e-05 1.521668000000e-09 3.409338000000e-05 1.525243000000e-09 2.865037000000e-05 1.529365000000e-09 2.366545000000e-05 1.532875000000e-09 2.030119000000e-05 1.534025000000e-09 1.935006000000e-05 1.534117000000e-09 -1.320855000000e-03 1.534180000000e-09 -2.228333000000e-03 1.534382000000e-09 -4.840587000000e-03 1.534737000000e-09 -8.557405000000e-03 1.535025000000e-09 -1.068638000000e-02 1.535086000000e-09 -1.022568000000e-02 1.535120000000e-09 -9.965097000000e-03 1.535227000000e-09 -9.170764000000e-03 1.535516000000e-09 -7.259985000000e-03 1.535770000000e-09 -5.861946000000e-03 1.536253000000e-09 -3.747939000000e-03 1.537797000000e-09 2.412428000000e-04 1.540037000000e-09 2.442332000000e-03 1.542991000000e-09 2.683711000000e-03 1.546340000000e-09 1.539077000000e-03 1.549563000000e-09 5.649725000000e-04 1.553023000000e-09 -8.188216000000e-05 1.556674000000e-09 -3.315343000000e-04 1.561332000000e-09 -2.886928000000e-04 1.564959000000e-09 -1.778983000000e-04 1.568637000000e-09 -9.910042000000e-05 1.572862000000e-09 -4.698537000000e-05 1.576410000000e-09 -2.359268000000e-05 1.580380000000e-09 -7.831478000000e-06 1.584817000000e-09 -2.010746000000e-06 1.588226000000e-09 3.480705000000e-06 1.592181000000e-09 3.187168000000e-06 1.595925000000e-09 6.497881000000e-06 1.599741000000e-09 4.727813000000e-06 1.604581000000e-09 7.399907000000e-06 1.606342000000e-09 6.704678000000e-06 1.608103000000e-09 5.119995000000e-06 1.611836000000e-09 7.594846000000e-06 1.616035000000e-09 5.165588000000e-06 1.619218000000e-09 7.665655000000e-06 1.623182000000e-09 5.131642000000e-06 1.626358000000e-09 7.700751000000e-06 1.629985000000e-09 5.086555000000e-06 1.634074000000e-09 7.750949000000e-06 1.638238000000e-09 5.017731000000e-06 1.643068000000e-09 7.741403000000e-06 1.648476000000e-09 4.964432000000e-06 1.653917000000e-09 7.733188000000e-06 1.658595000000e-09 4.930196000000e-06 1.665047000000e-09 7.739953000000e-06 1.668427000000e-09 4.905720000000e-06 1.674362000000e-09 7.761241000000e-06 1.678501000000e-09 4.884057000000e-06 1.684581000000e-09 7.770376000000e-06 1.686093000000e-09 6.300662000000e-06 1.687486000000e-09 6.320650000000e-06 1.691945000000e-09 6.285859000000e-06 1.695547000000e-09 6.288672000000e-06 1.700342000000e-09 6.271317000000e-06 1.704014000000e-09 6.279589000000e-06 1.707642000000e-09 6.268158000000e-06 1.712914000000e-09 6.276664000000e-06 1.717024000000e-09 6.266911000000e-06 1.722796000000e-09 6.275361000000e-06 1.724262000000e-09 6.271056000000e-06 1.725743000000e-09 6.270664000000e-06 1.730482000000e-09 6.270686000000e-06 1.734128000000e-09 6.270342000000e-06 1.739613000000e-09 6.270395000000e-06 1.743241000000e-09 6.270081000000e-06 1.746998000000e-09 6.270212000000e-06 1.752400000000e-09 6.269874000000e-06 1.756586000000e-09 6.270006000000e-06 1.762468000000e-09 6.269710000000e-06 1.764025000000e-09 6.269812000000e-06 1.765380000000e-09 6.269760000000e-06 1.769719000000e-09 6.269702000000e-06 1.773264000000e-09 6.269673000000e-06 1.778028000000e-09 6.269623000000e-06 1.781718000000e-09 6.269590000000e-06 1.785310000000e-09 6.269552000000e-06 1.790811000000e-09 6.269508000000e-06 1.794844000000e-09 6.269477000000e-06 1.800637000000e-09 6.269449000000e-06 1.802097000000e-09 6.269451000000e-06 1.803580000000e-09 6.269414000000e-06 1.808326000000e-09 6.269382000000e-06 1.811970000000e-09 6.269374000000e-06 1.817496000000e-09 6.269348000000e-06 1.821120000000e-09 6.269322000000e-06 1.824884000000e-09 6.269312000000e-06 1.830308000000e-09 6.269298000000e-06 1.834495000000e-09 6.269283000000e-06 1.840377000000e-09 6.269267000000e-06 1.841939000000e-09 6.269272000000e-06 1.843284000000e-09 6.269249000000e-06 1.847586000000e-09 6.269233000000e-06 1.851115000000e-09 6.269231000000e-06 1.855851000000e-09 6.269219000000e-06 1.859543000000e-09 6.269211000000e-06 1.863125000000e-09 6.269202000000e-06 1.868621000000e-09 6.269189000000e-06 1.872640000000e-09 6.269183000000e-06 1.878406000000e-09 6.269171000000e-06 1.879857000000e-09 6.269178000000e-06 1.881342000000e-09 6.269163000000e-06 1.886097000000e-09 6.269154000000e-06 1.889729000000e-09 6.269154000000e-06 1.895406000000e-09 6.269146000000e-06 1.899019000000e-09 6.269154000000e-06 1.902802000000e-09 6.269132000000e-06 1.908327000000e-09 6.269126000000e-06 1.912510000000e-09 6.269123000000e-06 1.918396000000e-09 6.269116000000e-06 1.923452000000e-09 6.269113000000e-06 1.928319000000e-09 6.269107000000e-06 1.933832000000e-09 6.269103000000e-06 1.937865000000e-09 6.269099000000e-06 1.941516000000e-09 6.269097000000e-06 1.947123000000e-09 6.269092000000e-06 1.951206000000e-09 6.269090000000e-06 1.957151000000e-09 6.269085000000e-06 1.962202000000e-09 6.269083000000e-06 1.967100000000e-09 6.269079000000e-06 1.968013000000e-09 6.269084000000e-06 1.969099000000e-09 6.269075000000e-06 1.972453000000e-09 6.269075000000e-06 1.975701000000e-09 6.269074000000e-06 1.979195000000e-09 6.269073000000e-06 1.983866000000e-09 6.269070000000e-06 1.987814000000e-09 6.269068000000e-06 1.993099000000e-09 6.269074000000e-06 1.998488000000e-09 6.269053000000e-06 2.003935000000e-09 6.269063000000e-06 2.004866000000e-09 6.269068000000e-06 2.005730000000e-09 6.269061000000e-06 2.008495000000e-09 6.269060000000e-06 2.013208000000e-09 6.269058000000e-06 2.016501000000e-09 6.269057000000e-06 2.021215000000e-09 6.269055000000e-06 2.025252000000e-09 6.269053000000e-06 2.030301000000e-09 6.269051000000e-06 2.035760000000e-09 6.269050000000e-06 2.040977000000e-09 6.269048000000e-06 2.042009000000e-09 6.269052000000e-06 2.042812000000e-09 6.269045000000e-06 2.045379000000e-09 6.269046000000e-06 2.049639000000e-09 6.269046000000e-06 2.053254000000e-09 6.269045000000e-06 2.056728000000e-09 6.269044000000e-06 2.062152000000e-09 6.269043000000e-06 2.066039000000e-09 6.269042000000e-06 2.071558000000e-09 6.269041000000e-06 2.076872000000e-09 6.269040000000e-06 2.078300000000e-09 6.269044000000e-06 2.079144000000e-09 6.269034000000e-06 2.081843000000e-09 6.269038000000e-06 2.085459000000e-09 6.269038000000e-06 2.089564000000e-09 6.269037000000e-06 2.093109000000e-09 6.269037000000e-06 2.096789000000e-09 6.269036000000e-06 2.101106000000e-09 6.269035000000e-06 2.105378000000e-09 6.269034000000e-06 2.110838000000e-09 6.269033000000e-06 2.112251000000e-09 6.269038000000e-06 2.113753000000e-09 6.269028000000e-06 2.118558000000e-09 6.269033000000e-06 2.122133000000e-09 6.269032000000e-06 2.129360000000e-09 6.269031000000e-06 2.132821000000e-09 6.269031000000e-06 2.136929000000e-09 6.269030000000e-06 2.139763000000e-09 6.269029000000e-06 2.142597000000e-09 6.269029000000e-06 2.147012000000e-09 6.269029000000e-06 2.152765000000e-09 6.269028000000e-06 2.154377000000e-09 6.269032000000e-06 2.155442000000e-09 6.269022000000e-06 2.158852000000e-09 6.269027000000e-06 2.162621000000e-09 6.269027000000e-06 2.166944000000e-09 6.269037000000e-06 2.170618000000e-09 6.269022000000e-06 2.174167000000e-09 6.269023000000e-06 2.179170000000e-09 6.269024000000e-06 2.183292000000e-09 6.269024000000e-06 2.188867000000e-09 6.269024000000e-06 2.190278000000e-09 6.269027000000e-06 2.191779000000e-09 6.269020000000e-06 2.196584000000e-09 6.269024000000e-06 2.200169000000e-09 6.269023000000e-06 2.207050000000e-09 6.269023000000e-06 2.210543000000e-09 6.269022000000e-06 2.214570000000e-09 6.269022000000e-06 2.217383000000e-09 6.269022000000e-06 2.220196000000e-09 6.269022000000e-06 2.224548000000e-09 6.269021000000e-06 2.230327000000e-09 6.269021000000e-06 2.231668000000e-09 6.269023000000e-06 2.232487000000e-09 6.269019000000e-06 2.235108000000e-09 6.269020000000e-06 2.238430000000e-09 6.269020000000e-06 2.242101000000e-09 6.269020000000e-06 2.245250000000e-09 6.269020000000e-06 2.248623000000e-09 6.269020000000e-06 2.252399000000e-09 6.269020000000e-06 2.256336000000e-09 6.269019000000e-06 2.261919000000e-09 6.269019000000e-06 2.264384000000e-09 6.269021000000e-06 2.265883000000e-09 6.269019000000e-06 2.270679000000e-09 6.269015000000e-06 2.277378000000e-09 6.269021000000e-06 2.283984000000e-09 6.269017000000e-06 2.291963000000e-09 6.269018000000e-06 2.303337000000e-09 6.269017000000e-06 2.323042000000e-09 6.269016000000e-06 2.352076000000e-09 6.269015000000e-06 2.407975000000e-09 6.269013000000e-06 2.543499000000e-09 6.269011000000e-06 2.778736000000e-09 6.269009000000e-06 3.128736000000e-09 6.269008000000e-06 3.478736000000e-09 6.269008000000e-06 3.828736000000e-09 6.269007000000e-06 4.076000000000e-09 6.269008000000e-06 4.076500000000e-09 2.038894000000e-02 4.077000000000e-09 4.008569000000e-02 4.077306000000e-09 3.906381000000e-02 4.077515000000e-09 3.826665000000e-02 4.078112000000e-09 3.572767000000e-02 4.079900000000e-09 2.851080000000e-02 4.082540000000e-09 1.954770000000e-02 4.086501000000e-09 1.039432000000e-02 4.092049000000e-09 3.780496000000e-03 4.100074000000e-09 6.746008000000e-04 4.112222000000e-09 -3.134022000000e-05 4.128358000000e-09 2.199822000000e-05 4.151784000000e-09 -4.195377000000e-06 4.181738000000e-09 1.635147000000e-05 4.223091000000e-09 -1.027578000000e-06 4.287381000000e-09 1.497471000000e-05 4.412795000000e-09 -6.570988000000e-07 4.639879000000e-09 1.494962000000e-05 4.989879000000e-09 -1.075778000000e-06 5.339879000000e-09 1.531100000000e-05 5.689879000000e-09 -1.377278000000e-06 6.039879000000e-09 1.560399000000e-05 6.389879000000e-09 -1.678801000000e-06 6.739879000000e-09 1.585948000000e-05 7.000000000000e-09 -1.968916000000e-06)
V_XOR_07 xor_07 0 PWL(0.000000000000e+00 6.995221000000e-06 1.000000000000e-12 6.997984000000e-06 2.000000000000e-12 7.000502000000e-06 5.200000000000e-12 7.006871000000e-06 1.544000000000e-11 7.014253000000e-06 4.820800000000e-11 7.014547000000e-06 1.530656000000e-10 7.014629000000e-06 4.886099000000e-10 7.014537000000e-06 8.386099000000e-10 7.014631000000e-06 9.995000000000e-10 7.014537000000e-06 9.996500000000e-10 7.014541000000e-06 1.000130000000e-09 7.014550000000e-06 1.000271000000e-09 7.014553000000e-06 1.000500000000e-09 7.014556000000e-06 1.000549000000e-09 7.014557000000e-06 1.000579000000e-09 7.014557000000e-06 1.000674000000e-09 7.014559000000e-06 1.000921000000e-09 7.014561000000e-06 1.001177000000e-09 7.014564000000e-06 1.001636000000e-09 7.014567000000e-06 1.002995000000e-09 7.014574000000e-06 1.004717000000e-09 7.014578000000e-06 1.007157000000e-09 7.014583000000e-06 1.009530000000e-09 7.014585000000e-06 1.012064000000e-09 7.014586000000e-06 1.014479000000e-09 7.014587000000e-06 1.016999000000e-09 7.014587000000e-06 1.019780000000e-09 7.014587000000e-06 1.023006000000e-09 7.014586000000e-06 1.025715000000e-09 7.014586000000e-06 1.028767000000e-09 7.014585000000e-06 1.031545000000e-09 7.014585000000e-06 1.034548000000e-09 7.014585000000e-06 1.037295000000e-09 7.014585000000e-06 1.040188000000e-09 7.014584000000e-06 1.042931000000e-09 7.014584000000e-06 1.046095000000e-09 7.014584000000e-06 1.049020000000e-09 7.014584000000e-06 1.051920000000e-09 7.014584000000e-06 1.055268000000e-09 7.014584000000e-06 1.057963000000e-09 7.014585000000e-06 1.059420000000e-09 7.014580000000e-06 1.060877000000e-09 7.014571000000e-06 1.063981000000e-09 7.014587000000e-06 1.066813000000e-09 7.014598000000e-06 1.069715000000e-09 7.014634000000e-06 1.073141000000e-09 7.014714000000e-06 1.075000000000e-09 7.014788000000e-06 1.075500000000e-09 -2.045888000000e-02 1.075834000000e-09 -3.391895000000e-02 1.076000000000e-09 -4.043046000000e-02 1.076266000000e-09 -3.910846000000e-02 1.076419000000e-09 -3.826786000000e-02 1.076822000000e-09 -3.580911000000e-02 1.078112000000e-09 -2.860478000000e-02 1.079915000000e-09 -2.077673000000e-02 1.082834000000e-09 -1.253812000000e-02 1.086452000000e-09 -6.732491000000e-03 1.089863000000e-09 -3.811578000000e-03 1.094093000000e-09 -1.921659000000e-03 1.097558000000e-09 -1.165420000000e-03 1.101264000000e-09 -7.066676000000e-04 1.105520000000e-09 -4.347784000000e-04 1.109056000000e-09 -2.965005000000e-04 1.112992000000e-09 -2.148116000000e-04 1.115807000000e-09 -1.651062000000e-04 1.118621000000e-09 -1.226506000000e-04 1.121942000000e-09 -1.017314000000e-04 1.125724000000e-09 -8.979322000000e-05 1.129501000000e-09 -1.225326000000e-04 1.133249000000e-09 -1.532618000000e-04 1.135809000000e-09 -1.429589000000e-05 1.138369000000e-09 2.544850000000e-04 1.141791000000e-09 9.588826000000e-04 1.145734000000e-09 1.165264000000e-03 1.150017000000e-09 -3.377070000000e-03 1.153865000000e-09 -1.397608000000e-02 1.158361000000e-09 -1.850763000000e-02 1.161824000000e-09 1.211075000000e-02 1.165535000000e-09 9.574673000000e-02 1.169527000000e-09 2.046059000000e-01 1.173109000000e-09 2.874724000000e-01 1.177056000000e-09 3.708765000000e-01 1.179535000000e-09 4.269174000000e-01 1.182013000000e-09 4.857876000000e-01 1.185429000000e-09 5.647410000000e-01 1.189651000000e-09 6.454597000000e-01 1.193349000000e-09 6.966249000000e-01 1.197208000000e-09 7.338959000000e-01 1.200595000000e-09 7.571652000000e-01 1.204042000000e-09 7.760248000000e-01 1.207661000000e-09 7.935498000000e-01 1.212044000000e-09 8.118454000000e-01 1.215603000000e-09 8.235545000000e-01 1.219624000000e-09 8.335008000000e-01 1.222280000000e-09 8.384261000000e-01 1.224935000000e-09 8.420448000000e-01 1.228316000000e-09 8.455658000000e-01 1.229186000000e-09 8.463158000000e-01 1.230042000000e-09 8.470334000000e-01 1.232779000000e-09 8.490773000000e-01 1.235670000000e-09 8.508498000000e-01 1.238863000000e-09 8.524015000000e-01 1.243639000000e-09 8.540472000000e-01 1.246999000000e-09 8.548624000000e-01 1.250850000000e-09 8.556927000000e-01 1.255187000000e-09 8.565526000000e-01 1.258822000000e-09 8.571669000000e-01 1.259631000000e-09 8.572878000000e-01 1.260438000000e-09 8.574063000000e-01 1.263021000000e-09 8.577596000000e-01 1.265957000000e-09 8.581175000000e-01 1.269137000000e-09 8.584578000000e-01 1.273131000000e-09 8.588185000000e-01 1.276658000000e-09 8.590785000000e-01 1.280195000000e-09 8.592896000000e-01 1.284359000000e-09 8.594829000000e-01 1.288216000000e-09 8.596169000000e-01 1.291735000000e-09 8.597093000000e-01 1.292574000000e-09 8.597272000000e-01 1.293423000000e-09 8.597448000000e-01 1.296139000000e-09 8.597939000000e-01 1.299136000000e-09 8.598360000000e-01 1.302736000000e-09 8.598737000000e-01 1.306959000000e-09 8.599074000000e-01 1.310392000000e-09 8.599270000000e-01 1.314112000000e-09 8.599381000000e-01 1.317424000000e-09 8.599531000000e-01 1.320972000000e-09 8.600116000000e-01 1.324632000000e-09 8.600896000000e-01 1.327145000000e-09 8.601192000000e-01 1.329658000000e-09 8.601294000000e-01 1.333049000000e-09 8.601093000000e-01 1.337028000000e-09 8.599912000000e-01 1.341293000000e-09 8.595613000000e-01 1.345153000000e-09 8.589292000000e-01 1.349994000000e-09 8.578054000000e-01 1.353616000000e-09 8.562778000000e-01 1.357116000000e-09 8.555625000000e-01 1.357983000000e-09 8.561251000000e-01 1.358962000000e-09 8.571174000000e-01 1.362092000000e-09 8.650272000000e-01 1.364885000000e-09 8.770729000000e-01 1.369987000000e-09 9.010862000000e-01 1.373500000000e-09 9.092862000000e-01 1.377230000000e-09 8.835735000000e-01 1.381288000000e-09 7.859662000000e-01 1.384815000000e-09 6.503639000000e-01 1.388662000000e-09 4.808595000000e-01 1.389532000000e-09 4.431351000000e-01 1.390483000000e-09 4.033064000000e-01 1.393528000000e-09 2.910976000000e-01 1.396267000000e-09 2.073298000000e-01 1.399530000000e-09 1.337520000000e-01 1.403009000000e-09 8.493134000000e-02 1.406745000000e-09 5.432950000000e-02 1.410579000000e-09 3.698051000000e-02 1.413057000000e-09 2.971088000000e-02 1.415535000000e-09 2.553960000000e-02 1.418933000000e-09 2.086253000000e-02 1.419781000000e-09 1.979356000000e-02 1.420563000000e-09 1.881737000000e-02 1.423064000000e-09 1.571491000000e-02 1.426220000000e-09 1.204171000000e-02 1.429627000000e-09 8.654040000000e-03 1.432942000000e-09 6.069693000000e-03 1.436511000000e-09 4.047313000000e-03 1.439973000000e-09 2.725728000000e-03 1.444113000000e-09 1.734834000000e-03 1.447667000000e-09 1.222451000000e-03 1.448597000000e-09 1.129065000000e-03 1.449278000000e-09 1.063677000000e-03 1.451458000000e-09 8.884241000000e-04 1.454984000000e-09 6.921107000000e-04 1.458241000000e-09 5.825938000000e-04 1.461761000000e-09 5.241094000000e-04 1.465886000000e-09 5.354992000000e-04 1.469389000000e-09 6.007824000000e-04 1.472794000000e-09 6.849709000000e-04 1.475276000000e-09 7.479520000000e-04 1.477758000000e-09 8.122963000000e-04 1.479095000000e-09 8.417877000000e-04 1.479882000000e-09 8.588389000000e-04 1.482402000000e-09 9.046475000000e-04 1.485321000000e-09 9.349579000000e-04 1.488790000000e-09 9.345382000000e-04 1.492381000000e-09 8.962818000000e-04 1.496661000000e-09 8.152974000000e-04 1.500576000000e-09 7.222680000000e-04 1.504103000000e-09 6.336489000000e-04 1.508121000000e-09 5.356569000000e-04 1.509046000000e-09 5.142759000000e-04 1.509764000000e-09 4.978389000000e-04 1.512062000000e-09 4.474783000000e-04 1.514727000000e-09 3.935381000000e-04 1.518391000000e-09 3.275007000000e-04 1.521668000000e-09 2.763115000000e-04 1.525243000000e-09 2.284851000000e-04 1.529365000000e-09 1.827116000000e-04 1.532875000000e-09 1.506770000000e-04 1.534025000000e-09 1.414384000000e-04 1.534117000000e-09 -1.193481000000e-03 1.534180000000e-09 -2.102803000000e-03 1.534382000000e-09 -4.721622000000e-03 1.534737000000e-09 -8.447944000000e-03 1.535025000000e-09 -1.058377000000e-02 1.535086000000e-09 -1.012351000000e-02 1.535120000000e-09 -9.863270000000e-03 1.535227000000e-09 -9.070063000000e-03 1.535516000000e-09 -7.161065000000e-03 1.535770000000e-09 -5.762776000000e-03 1.536253000000e-09 -3.645322000000e-03 1.537797000000e-09 3.560595000000e-04 1.540037000000e-09 2.576174000000e-03 1.542991000000e-09 2.809481000000e-03 1.546340000000e-09 1.630818000000e-03 1.549563000000e-09 6.232265000000e-04 1.553023000000e-09 -4.611819000000e-05 1.556674000000e-09 -3.115372000000e-04 1.561332000000e-09 -2.790829000000e-04 1.564959000000e-09 -1.728434000000e-04 1.568637000000e-09 -9.616079000000e-05 1.572862000000e-09 -4.561764000000e-05 1.576410000000e-09 -2.269592000000e-05 1.580380000000e-09 -7.466383000000e-06 1.584817000000e-09 -1.686019000000e-06 1.588226000000e-09 3.556514000000e-06 1.592181000000e-09 3.333328000000e-06 1.595925000000e-09 6.450153000000e-06 1.599741000000e-09 4.837829000000e-06 1.604581000000e-09 7.329081000000e-06 1.606342000000e-09 6.684954000000e-06 1.608103000000e-09 5.213729000000e-06 1.611836000000e-09 7.522559000000e-06 1.616035000000e-09 5.251704000000e-06 1.619218000000e-09 7.594822000000e-06 1.623182000000e-09 5.212614000000e-06 1.626358000000e-09 7.632750000000e-06 1.629985000000e-09 5.162931000000e-06 1.634074000000e-09 7.684440000000e-06 1.638238000000e-09 5.090222000000e-06 1.643068000000e-09 7.677111000000e-06 1.648476000000e-09 5.034041000000e-06 1.653917000000e-09 7.670269000000e-06 1.658595000000e-09 4.996797000000e-06 1.665047000000e-09 7.679155000000e-06 1.668427000000e-09 4.969558000000e-06 1.674362000000e-09 7.703273000000e-06 1.678501000000e-09 4.945589000000e-06 1.684581000000e-09 7.714310000000e-06 1.686093000000e-09 6.301603000000e-06 1.687486000000e-09 6.323339000000e-06 1.691945000000e-09 6.286385000000e-06 1.695547000000e-09 6.290670000000e-06 1.700342000000e-09 6.271623000000e-06 1.704014000000e-09 6.281392000000e-06 1.707642000000e-09 6.268435000000e-06 1.712914000000e-09 6.278393000000e-06 1.717024000000e-09 6.267189000000e-06 1.722796000000e-09 6.277052000000e-06 1.724262000000e-09 6.272053000000e-06 1.725743000000e-09 6.271641000000e-06 1.730482000000e-09 6.271680000000e-06 1.734128000000e-09 6.271316000000e-06 1.739613000000e-09 6.271386000000e-06 1.743241000000e-09 6.271054000000e-06 1.746998000000e-09 6.271202000000e-06 1.752400000000e-09 6.270847000000e-06 1.756586000000e-09 6.270995000000e-06 1.762468000000e-09 6.270682000000e-06 1.764025000000e-09 6.270793000000e-06 1.765380000000e-09 6.270741000000e-06 1.769719000000e-09 6.270682000000e-06 1.773264000000e-09 6.270654000000e-06 1.778028000000e-09 6.270603000000e-06 1.781718000000e-09 6.270570000000e-06 1.785310000000e-09 6.270532000000e-06 1.790811000000e-09 6.270488000000e-06 1.794844000000e-09 6.270457000000e-06 1.800637000000e-09 6.270429000000e-06 1.802097000000e-09 6.270431000000e-06 1.803580000000e-09 6.270394000000e-06 1.808326000000e-09 6.270361000000e-06 1.811970000000e-09 6.270354000000e-06 1.817496000000e-09 6.270328000000e-06 1.821120000000e-09 6.270302000000e-06 1.824884000000e-09 6.270292000000e-06 1.830308000000e-09 6.270278000000e-06 1.834495000000e-09 6.270263000000e-06 1.840377000000e-09 6.270247000000e-06 1.841939000000e-09 6.270252000000e-06 1.843284000000e-09 6.270229000000e-06 1.847586000000e-09 6.270212000000e-06 1.851115000000e-09 6.270210000000e-06 1.855851000000e-09 6.270199000000e-06 1.859543000000e-09 6.270190000000e-06 1.863125000000e-09 6.270182000000e-06 1.868621000000e-09 6.270169000000e-06 1.872640000000e-09 6.270162000000e-06 1.878406000000e-09 6.270151000000e-06 1.879857000000e-09 6.270157000000e-06 1.881342000000e-09 6.270143000000e-06 1.886097000000e-09 6.270134000000e-06 1.889729000000e-09 6.270133000000e-06 1.895406000000e-09 6.270125000000e-06 1.899019000000e-09 6.270133000000e-06 1.902802000000e-09 6.270111000000e-06 1.908327000000e-09 6.270106000000e-06 1.912510000000e-09 6.270103000000e-06 1.918396000000e-09 6.270096000000e-06 1.923452000000e-09 6.270092000000e-06 1.928319000000e-09 6.270087000000e-06 1.933832000000e-09 6.270083000000e-06 1.937865000000e-09 6.270079000000e-06 1.941516000000e-09 6.270077000000e-06 1.947123000000e-09 6.270071000000e-06 1.951206000000e-09 6.270069000000e-06 1.957151000000e-09 6.270064000000e-06 1.962202000000e-09 6.270062000000e-06 1.967100000000e-09 6.270058000000e-06 1.968013000000e-09 6.270063000000e-06 1.969099000000e-09 6.270054000000e-06 1.972453000000e-09 6.270055000000e-06 1.975701000000e-09 6.270054000000e-06 1.979195000000e-09 6.270052000000e-06 1.983866000000e-09 6.270050000000e-06 1.987814000000e-09 6.270048000000e-06 1.993099000000e-09 6.270053000000e-06 1.998488000000e-09 6.270033000000e-06 2.003935000000e-09 6.270043000000e-06 2.004866000000e-09 6.270047000000e-06 2.005730000000e-09 6.270040000000e-06 2.008495000000e-09 6.270040000000e-06 2.013208000000e-09 6.270037000000e-06 2.016501000000e-09 6.270036000000e-06 2.021215000000e-09 6.270034000000e-06 2.025252000000e-09 6.270033000000e-06 2.030301000000e-09 6.270031000000e-06 2.035760000000e-09 6.270029000000e-06 2.040977000000e-09 6.270028000000e-06 2.042009000000e-09 6.270032000000e-06 2.042812000000e-09 6.270025000000e-06 2.045379000000e-09 6.270026000000e-06 2.049639000000e-09 6.270025000000e-06 2.053254000000e-09 6.270025000000e-06 2.056728000000e-09 6.270024000000e-06 2.062152000000e-09 6.270022000000e-06 2.066039000000e-09 6.270022000000e-06 2.071558000000e-09 6.270020000000e-06 2.076872000000e-09 6.270019000000e-06 2.078300000000e-09 6.270024000000e-06 2.079144000000e-09 6.270014000000e-06 2.081843000000e-09 6.270017000000e-06 2.085459000000e-09 6.270017000000e-06 2.089564000000e-09 6.270017000000e-06 2.093109000000e-09 6.270016000000e-06 2.096789000000e-09 6.270016000000e-06 2.101106000000e-09 6.270015000000e-06 2.105378000000e-09 6.270014000000e-06 2.110838000000e-09 6.270013000000e-06 2.112251000000e-09 6.270017000000e-06 2.113753000000e-09 6.270008000000e-06 2.118558000000e-09 6.270013000000e-06 2.122133000000e-09 6.270011000000e-06 2.129360000000e-09 6.270010000000e-06 2.132821000000e-09 6.270010000000e-06 2.136929000000e-09 6.270009000000e-06 2.139763000000e-09 6.270009000000e-06 2.142597000000e-09 6.270008000000e-06 2.147012000000e-09 6.270008000000e-06 2.152765000000e-09 6.270007000000e-06 2.154377000000e-09 6.270011000000e-06 2.155442000000e-09 6.270002000000e-06 2.158852000000e-09 6.270007000000e-06 2.162621000000e-09 6.270006000000e-06 2.166944000000e-09 6.270016000000e-06 2.170618000000e-09 6.270001000000e-06 2.174167000000e-09 6.270002000000e-06 2.179170000000e-09 6.270003000000e-06 2.183292000000e-09 6.270003000000e-06 2.188867000000e-09 6.270004000000e-06 2.190278000000e-09 6.270006000000e-06 2.191779000000e-09 6.270000000000e-06 2.196584000000e-09 6.270004000000e-06 2.200169000000e-09 6.270003000000e-06 2.207050000000e-09 6.270002000000e-06 2.210543000000e-09 6.270002000000e-06 2.214570000000e-09 6.270002000000e-06 2.217383000000e-09 6.270001000000e-06 2.220196000000e-09 6.270001000000e-06 2.224548000000e-09 6.270001000000e-06 2.230327000000e-09 6.270000000000e-06 2.231668000000e-09 6.270003000000e-06 2.232487000000e-09 6.269998000000e-06 2.235108000000e-09 6.270000000000e-06 2.238430000000e-09 6.270000000000e-06 2.242101000000e-09 6.270000000000e-06 2.245250000000e-09 6.270000000000e-06 2.248623000000e-09 6.269999000000e-06 2.252399000000e-09 6.269999000000e-06 2.256336000000e-09 6.269999000000e-06 2.261919000000e-09 6.269998000000e-06 2.264384000000e-09 6.270000000000e-06 2.265883000000e-09 6.269999000000e-06 2.270679000000e-09 6.269994000000e-06 2.277378000000e-09 6.270000000000e-06 2.283984000000e-09 6.269997000000e-06 2.291963000000e-09 6.269997000000e-06 2.303337000000e-09 6.269996000000e-06 2.323042000000e-09 6.269996000000e-06 2.352076000000e-09 6.269994000000e-06 2.407975000000e-09 6.269993000000e-06 2.543499000000e-09 6.269990000000e-06 2.778736000000e-09 6.269988000000e-06 3.128736000000e-09 6.269987000000e-06 3.478736000000e-09 6.269987000000e-06 3.828736000000e-09 6.269987000000e-06 4.076000000000e-09 6.269987000000e-06 4.076500000000e-09 2.038859000000e-02 4.077000000000e-09 4.008541000000e-02 4.077306000000e-09 3.906356000000e-02 4.077515000000e-09 3.826643000000e-02 4.078112000000e-09 3.572749000000e-02 4.079900000000e-09 2.851070000000e-02 4.082540000000e-09 1.954764000000e-02 4.086501000000e-09 1.039429000000e-02 4.092049000000e-09 3.780489000000e-03 4.100074000000e-09 6.745997000000e-04 4.112222000000e-09 -3.134017000000e-05 4.128358000000e-09 2.199821000000e-05 4.151784000000e-09 -4.195381000000e-06 4.181738000000e-09 1.635147000000e-05 4.223091000000e-09 -1.027589000000e-06 4.287381000000e-09 1.497471000000e-05 4.412795000000e-09 -6.571123000000e-07 4.639879000000e-09 1.494963000000e-05 4.989879000000e-09 -1.075791000000e-06 5.339879000000e-09 1.531101000000e-05 5.689879000000e-09 -1.377292000000e-06 6.039879000000e-09 1.560399000000e-05 6.389879000000e-09 -1.678815000000e-06 6.739879000000e-09 1.585949000000e-05 7.000000000000e-09 -1.968930000000e-06)
V_XOR_08 xor_08 0 PWL(0.000000000000e+00 6.995221000000e-06 1.000000000000e-12 6.997984000000e-06 2.000000000000e-12 7.000502000000e-06 5.200000000000e-12 7.006871000000e-06 1.544000000000e-11 7.014253000000e-06 4.820800000000e-11 7.014547000000e-06 1.530656000000e-10 7.014629000000e-06 4.886099000000e-10 7.014537000000e-06 8.386099000000e-10 7.014631000000e-06 9.995000000000e-10 7.014537000000e-06 9.996500000000e-10 7.014541000000e-06 1.000130000000e-09 7.014550000000e-06 1.000271000000e-09 7.014553000000e-06 1.000500000000e-09 7.014556000000e-06 1.000549000000e-09 7.014557000000e-06 1.000579000000e-09 7.014557000000e-06 1.000674000000e-09 7.014559000000e-06 1.000921000000e-09 7.014561000000e-06 1.001177000000e-09 7.014564000000e-06 1.001636000000e-09 7.014567000000e-06 1.002995000000e-09 7.014574000000e-06 1.004717000000e-09 7.014578000000e-06 1.007157000000e-09 7.014583000000e-06 1.009530000000e-09 7.014585000000e-06 1.012064000000e-09 7.014586000000e-06 1.014479000000e-09 7.014587000000e-06 1.016999000000e-09 7.014587000000e-06 1.019780000000e-09 7.014587000000e-06 1.023006000000e-09 7.014586000000e-06 1.025715000000e-09 7.014586000000e-06 1.028767000000e-09 7.014585000000e-06 1.031545000000e-09 7.014585000000e-06 1.034548000000e-09 7.014585000000e-06 1.037295000000e-09 7.014585000000e-06 1.040188000000e-09 7.014584000000e-06 1.042931000000e-09 7.014584000000e-06 1.046095000000e-09 7.014584000000e-06 1.049020000000e-09 7.014584000000e-06 1.051920000000e-09 7.014584000000e-06 1.055268000000e-09 7.014584000000e-06 1.057963000000e-09 7.014584000000e-06 1.059420000000e-09 7.014584000000e-06 1.060877000000e-09 7.014584000000e-06 1.063981000000e-09 7.014584000000e-06 1.066813000000e-09 7.014584000000e-06 1.069715000000e-09 7.014584000000e-06 1.073141000000e-09 7.014584000000e-06 1.075000000000e-09 7.014584000000e-06 1.075500000000e-09 -2.045888000000e-02 1.075834000000e-09 -3.391895000000e-02 1.076000000000e-09 -4.043047000000e-02 1.076266000000e-09 -3.910846000000e-02 1.076419000000e-09 -3.826786000000e-02 1.076822000000e-09 -3.580911000000e-02 1.078112000000e-09 -2.860478000000e-02 1.079915000000e-09 -2.077672000000e-02 1.082834000000e-09 -1.253812000000e-02 1.086452000000e-09 -6.732492000000e-03 1.089863000000e-09 -3.811583000000e-03 1.094093000000e-09 -1.921680000000e-03 1.097558000000e-09 -1.165445000000e-03 1.101264000000e-09 -7.065980000000e-04 1.105520000000e-09 -4.344238000000e-04 1.109056000000e-09 -2.959278000000e-04 1.112992000000e-09 -2.150756000000e-04 1.115807000000e-09 -1.673151000000e-04 1.118621000000e-09 -1.279274000000e-04 1.121942000000e-09 -1.059011000000e-04 1.125724000000e-09 -7.589635000000e-05 1.129501000000e-09 -6.361883000000e-05 1.133249000000e-09 -4.300631000000e-05 1.135809000000e-09 -3.415793000000e-05 1.138369000000e-09 -2.955284000000e-05 1.141791000000e-09 -1.734251000000e-05 1.145734000000e-09 -2.437858000000e-05 1.150017000000e-09 -5.769912000000e-05 1.153865000000e-09 -1.174015000000e-04 1.158361000000e-09 1.141973000000e-04 1.161824000000e-09 7.469192000000e-04 1.165535000000e-09 1.378096000000e-03 1.169527000000e-09 -7.583743000000e-04 1.173109000000e-09 -7.829032000000e-03 1.177056000000e-09 -2.061205000000e-02 1.179535000000e-09 -1.566165000000e-02 1.182013000000e-09 -6.997164000000e-04 1.185429000000e-09 6.277360000000e-02 1.189651000000e-09 1.761369000000e-01 1.193349000000e-09 2.668308000000e-01 1.197208000000e-09 3.484277000000e-01 1.200595000000e-09 4.241068000000e-01 1.204042000000e-09 5.057383000000e-01 1.207661000000e-09 5.863314000000e-01 1.212044000000e-09 6.637537000000e-01 1.215603000000e-09 7.080893000000e-01 1.219624000000e-09 7.429853000000e-01 1.222280000000e-09 7.608818000000e-01 1.224935000000e-09 7.746843000000e-01 1.228316000000e-09 7.910058000000e-01 1.229186000000e-09 7.949519000000e-01 1.230042000000e-09 7.987638000000e-01 1.232779000000e-09 8.099258000000e-01 1.235670000000e-09 8.199414000000e-01 1.238863000000e-09 8.289038000000e-01 1.243639000000e-09 8.384812000000e-01 1.246999000000e-09 8.429186000000e-01 1.250850000000e-09 8.466511000000e-01 1.255187000000e-09 8.498307000000e-01 1.258822000000e-09 8.518322000000e-01 1.259631000000e-09 8.521909000000e-01 1.260438000000e-09 8.525366000000e-01 1.263021000000e-09 8.534817000000e-01 1.265957000000e-09 8.543124000000e-01 1.269137000000e-09 8.550534000000e-01 1.273131000000e-09 8.559077000000e-01 1.276658000000e-09 8.565934000000e-01 1.280195000000e-09 8.571863000000e-01 1.284359000000e-09 8.577738000000e-01 1.288216000000e-09 8.582331000000e-01 1.291735000000e-09 8.585902000000e-01 1.292574000000e-09 8.586652000000e-01 1.293423000000e-09 8.587395000000e-01 1.296139000000e-09 8.589556000000e-01 1.299136000000e-09 8.591578000000e-01 1.302736000000e-09 8.593557000000e-01 1.306959000000e-09 8.595342000000e-01 1.310392000000e-09 8.596440000000e-01 1.314112000000e-09 8.597348000000e-01 1.317424000000e-09 8.597962000000e-01 1.320972000000e-09 8.598465000000e-01 1.324632000000e-09 8.598847000000e-01 1.327145000000e-09 8.599052000000e-01 1.329658000000e-09 8.599208000000e-01 1.333049000000e-09 8.599376000000e-01 1.337028000000e-09 8.599515000000e-01 1.341293000000e-09 8.599602000000e-01 1.345153000000e-09 8.599663000000e-01 1.349994000000e-09 8.599719000000e-01 1.353616000000e-09 8.599702000000e-01 1.357116000000e-09 8.599852000000e-01 1.357983000000e-09 8.599971000000e-01 1.358962000000e-09 8.600130000000e-01 1.362092000000e-09 8.600788000000e-01 1.364885000000e-09 8.601213000000e-01 1.369987000000e-09 8.601324000000e-01 1.373500000000e-09 8.600889000000e-01 1.377230000000e-09 8.598954000000e-01 1.381288000000e-09 8.593805000000e-01 1.384815000000e-09 8.587765000000e-01 1.388662000000e-09 8.578770000000e-01 1.389532000000e-09 8.575793000000e-01 1.390483000000e-09 8.572143000000e-01 1.393528000000e-09 8.557608000000e-01 1.396267000000e-09 8.555601000000e-01 1.399530000000e-09 8.605809000000e-01 1.403009000000e-09 8.736021000000e-01 1.406745000000e-09 8.917706000000e-01 1.410579000000e-09 9.072191000000e-01 1.413057000000e-09 9.029342000000e-01 1.415535000000e-09 8.874423000000e-01 1.418933000000e-09 8.191531000000e-01 1.419781000000e-09 7.920227000000e-01 1.420563000000e-09 7.657829000000e-01 1.423064000000e-09 6.700438000000e-01 1.426220000000e-09 5.329724000000e-01 1.429627000000e-09 3.881783000000e-01 1.432942000000e-09 2.698404000000e-01 1.436511000000e-09 1.706085000000e-01 1.439973000000e-09 1.073539000000e-01 1.444113000000e-09 6.381370000000e-02 1.447667000000e-09 4.335624000000e-02 1.448597000000e-09 3.993008000000e-02 1.449278000000e-09 3.756537000000e-02 1.451458000000e-09 3.149203000000e-02 1.454984000000e-09 2.487654000000e-02 1.458241000000e-09 2.036372000000e-02 1.461761000000e-09 1.588203000000e-02 1.465886000000e-09 1.109874000000e-02 1.469389000000e-09 7.791795000000e-03 1.472794000000e-09 5.362746000000e-03 1.475276000000e-09 4.012036000000e-03 1.477758000000e-09 3.015299000000e-03 1.479095000000e-09 2.625615000000e-03 1.479882000000e-09 2.407614000000e-03 1.482402000000e-09 1.837968000000e-03 1.485321000000e-09 1.370784000000e-03 1.488790000000e-09 9.994566000000e-04 1.492381000000e-09 7.572820000000e-04 1.496661000000e-09 5.905721000000e-04 1.500576000000e-09 5.231973000000e-04 1.504103000000e-09 5.295785000000e-04 1.508121000000e-09 6.004507000000e-04 1.509046000000e-09 6.222626000000e-04 1.509764000000e-09 6.395890000000e-04 1.512062000000e-09 6.975334000000e-04 1.514727000000e-09 7.673180000000e-04 1.518391000000e-09 8.571554000000e-04 1.521668000000e-09 9.162374000000e-04 1.525243000000e-09 9.428417000000e-04 1.529365000000e-09 9.217313000000e-04 1.532875000000e-09 8.677259000000e-04 1.534025000000e-09 8.445229000000e-04 1.534117000000e-09 -4.648367000000e-04 1.534180000000e-09 -1.386511000000e-03 1.534382000000e-09 -4.048201000000e-03 1.534737000000e-09 -7.844321000000e-03 1.535025000000e-09 -1.002595000000e-02 1.535086000000e-09 -9.569078000000e-03 1.535120000000e-09 -9.311152000000e-03 1.535227000000e-09 -8.525340000000e-03 1.535516000000e-09 -6.624530000000e-03 1.535770000000e-09 -5.215835000000e-03 1.536253000000e-09 -3.048699000000e-03 1.537797000000e-09 1.153304000000e-03 1.540037000000e-09 3.663705000000e-03 1.542991000000e-09 3.901588000000e-03 1.546340000000e-09 2.440022000000e-03 1.549563000000e-09 1.140989000000e-03 1.553023000000e-09 2.711464000000e-04 1.556674000000e-09 -1.322404000000e-04 1.561332000000e-09 -1.930243000000e-04 1.564959000000e-09 -1.273537000000e-04 1.568637000000e-09 -6.990164000000e-05 1.572862000000e-09 -3.281511000000e-05 1.576410000000e-09 -1.570439000000e-05 1.580380000000e-09 -4.325972000000e-06 1.584817000000e-09 1.102738000000e-06 1.588226000000e-09 4.008730000000e-06 1.592181000000e-09 4.651191000000e-06 1.595925000000e-09 6.158743000000e-06 1.599741000000e-09 5.719574000000e-06 1.604581000000e-09 6.819037000000e-06 1.606342000000e-09 6.552594000000e-06 1.608103000000e-09 5.930641000000e-06 1.611836000000e-09 6.981292000000e-06 1.616035000000e-09 5.900431000000e-06 1.619218000000e-09 7.052423000000e-06 1.623182000000e-09 5.824100000000e-06 1.626358000000e-09 7.105755000000e-06 1.629985000000e-09 5.741175000000e-06 1.634074000000e-09 7.141169000000e-06 1.638238000000e-09 5.657638000000e-06 1.643068000000e-09 7.153615000000e-06 1.648476000000e-09 5.583333000000e-06 1.653917000000e-09 7.158970000000e-06 1.658595000000e-09 5.527448000000e-06 1.665047000000e-09 7.181475000000e-06 1.668427000000e-09 5.480739000000e-06 1.674362000000e-09 7.224678000000e-06 1.678501000000e-09 5.440836000000e-06 1.684581000000e-09 7.248896000000e-06 1.686093000000e-09 6.307595000000e-06 1.687486000000e-09 6.338571000000e-06 1.691945000000e-09 6.287861000000e-06 1.695547000000e-09 6.302109000000e-06 1.700342000000e-09 6.271373000000e-06 1.704014000000e-09 6.291402000000e-06 1.707642000000e-09 6.267903000000e-06 1.712914000000e-09 6.287900000000e-06 1.717024000000e-09 6.266611000000e-06 1.722796000000e-09 6.286292000000e-06 1.724262000000e-09 6.276471000000e-06 1.725743000000e-09 6.275923000000e-06 1.730482000000e-09 6.276046000000e-06 1.734128000000e-09 6.275566000000e-06 1.739613000000e-09 6.275752000000e-06 1.743241000000e-09 6.275295000000e-06 1.746998000000e-09 6.275534000000e-06 1.752400000000e-09 6.275082000000e-06 1.756586000000e-09 6.275330000000e-06 1.762468000000e-09 6.274923000000e-06 1.764025000000e-09 6.275078000000e-06 1.765380000000e-09 6.275022000000e-06 1.769719000000e-09 6.274945000000e-06 1.773264000000e-09 6.274931000000e-06 1.778028000000e-09 6.274879000000e-06 1.781718000000e-09 6.274845000000e-06 1.785310000000e-09 6.274806000000e-06 1.790811000000e-09 6.274771000000e-06 1.794844000000e-09 6.274727000000e-06 1.800637000000e-09 6.274689000000e-06 1.802097000000e-09 6.274697000000e-06 1.803580000000e-09 6.274663000000e-06 1.808326000000e-09 6.274634000000e-06 1.811970000000e-09 6.274625000000e-06 1.817496000000e-09 6.274589000000e-06 1.821120000000e-09 6.274581000000e-06 1.824884000000e-09 6.274580000000e-06 1.830308000000e-09 6.274541000000e-06 1.834495000000e-09 6.274530000000e-06 1.840377000000e-09 6.274506000000e-06 1.841939000000e-09 6.274516000000e-06 1.843284000000e-09 6.274497000000e-06 1.847586000000e-09 6.274483000000e-06 1.851115000000e-09 6.274480000000e-06 1.855851000000e-09 6.274468000000e-06 1.859543000000e-09 6.274459000000e-06 1.863125000000e-09 6.274450000000e-06 1.868621000000e-09 6.274438000000e-06 1.872640000000e-09 6.274431000000e-06 1.878406000000e-09 6.274429000000e-06 1.879857000000e-09 6.274430000000e-06 1.881342000000e-09 6.274411000000e-06 1.886097000000e-09 6.274399000000e-06 1.889729000000e-09 6.274400000000e-06 1.895406000000e-09 6.274393000000e-06 1.899019000000e-09 6.274389000000e-06 1.902802000000e-09 6.274383000000e-06 1.908327000000e-09 6.274376000000e-06 1.912510000000e-09 6.274372000000e-06 1.918396000000e-09 6.274365000000e-06 1.923452000000e-09 6.274360000000e-06 1.928319000000e-09 6.274355000000e-06 1.933832000000e-09 6.274350000000e-06 1.937865000000e-09 6.274347000000e-06 1.941516000000e-09 6.274344000000e-06 1.947123000000e-09 6.274340000000e-06 1.951206000000e-09 6.274337000000e-06 1.957151000000e-09 6.274341000000e-06 1.962202000000e-09 6.274325000000e-06 1.967100000000e-09 6.274325000000e-06 1.968013000000e-09 6.274330000000e-06 1.969099000000e-09 6.274321000000e-06 1.972453000000e-09 6.274322000000e-06 1.975701000000e-09 6.274321000000e-06 1.979195000000e-09 6.274320000000e-06 1.983866000000e-09 6.274317000000e-06 1.987814000000e-09 6.274316000000e-06 1.993099000000e-09 6.274312000000e-06 1.998488000000e-09 6.274306000000e-06 2.003935000000e-09 6.274312000000e-06 2.004866000000e-09 6.274316000000e-06 2.005730000000e-09 6.274309000000e-06 2.008495000000e-09 6.274308000000e-06 2.013208000000e-09 6.274305000000e-06 2.016501000000e-09 6.274304000000e-06 2.021215000000e-09 6.274302000000e-06 2.025252000000e-09 6.274301000000e-06 2.030301000000e-09 6.274299000000e-06 2.035760000000e-09 6.274297000000e-06 2.040977000000e-09 6.274296000000e-06 2.042009000000e-09 6.274299000000e-06 2.042812000000e-09 6.274293000000e-06 2.045379000000e-09 6.274294000000e-06 2.049639000000e-09 6.274293000000e-06 2.053254000000e-09 6.274293000000e-06 2.056728000000e-09 6.274292000000e-06 2.062152000000e-09 6.274290000000e-06 2.066039000000e-09 6.274289000000e-06 2.071558000000e-09 6.274288000000e-06 2.076872000000e-09 6.274287000000e-06 2.078300000000e-09 6.274292000000e-06 2.079144000000e-09 6.274281000000e-06 2.081843000000e-09 6.274285000000e-06 2.085459000000e-09 6.274285000000e-06 2.089564000000e-09 6.274285000000e-06 2.093109000000e-09 6.274284000000e-06 2.096789000000e-09 6.274295000000e-06 2.101106000000e-09 6.274277000000e-06 2.105378000000e-09 6.274279000000e-06 2.110838000000e-09 6.274280000000e-06 2.112251000000e-09 6.274284000000e-06 2.113753000000e-09 6.274275000000e-06 2.118558000000e-09 6.274280000000e-06 2.122133000000e-09 6.274279000000e-06 2.129360000000e-09 6.274278000000e-06 2.132821000000e-09 6.274278000000e-06 2.136929000000e-09 6.274277000000e-06 2.139763000000e-09 6.274277000000e-06 2.142597000000e-09 6.274276000000e-06 2.147012000000e-09 6.274276000000e-06 2.152765000000e-09 6.274275000000e-06 2.154377000000e-09 6.274279000000e-06 2.155442000000e-09 6.274270000000e-06 2.158852000000e-09 6.274274000000e-06 2.162621000000e-09 6.274274000000e-06 2.166944000000e-09 6.274274000000e-06 2.170618000000e-09 6.274273000000e-06 2.174167000000e-09 6.274273000000e-06 2.179170000000e-09 6.274272000000e-06 2.183292000000e-09 6.274272000000e-06 2.188867000000e-09 6.274271000000e-06 2.190278000000e-09 6.274274000000e-06 2.191779000000e-09 6.274268000000e-06 2.196584000000e-09 6.274271000000e-06 2.200169000000e-09 6.274270000000e-06 2.207050000000e-09 6.274270000000e-06 2.210543000000e-09 6.274270000000e-06 2.214570000000e-09 6.274269000000e-06 2.217383000000e-09 6.274269000000e-06 2.220196000000e-09 6.274269000000e-06 2.224548000000e-09 6.274268000000e-06 2.230327000000e-09 6.274268000000e-06 2.231668000000e-09 6.274270000000e-06 2.232487000000e-09 6.274266000000e-06 2.235108000000e-09 6.274267000000e-06 2.238430000000e-09 6.274267000000e-06 2.242101000000e-09 6.274267000000e-06 2.245250000000e-09 6.274267000000e-06 2.248623000000e-09 6.274267000000e-06 2.252399000000e-09 6.274267000000e-06 2.256336000000e-09 6.274266000000e-06 2.261919000000e-09 6.274266000000e-06 2.264384000000e-09 6.274268000000e-06 2.265883000000e-09 6.274266000000e-06 2.270679000000e-09 6.274262000000e-06 2.277378000000e-09 6.274268000000e-06 2.283984000000e-09 6.274264000000e-06 2.291963000000e-09 6.274265000000e-06 2.303337000000e-09 6.274264000000e-06 2.323042000000e-09 6.274263000000e-06 2.352076000000e-09 6.274262000000e-06 2.407975000000e-09 6.274261000000e-06 2.543499000000e-09 6.274257000000e-06 2.778736000000e-09 6.274257000000e-06 3.128736000000e-09 6.274254000000e-06 3.478736000000e-09 6.274255000000e-06 3.828736000000e-09 6.274254000000e-06 4.076000000000e-09 6.274255000000e-06 4.076500000000e-09 2.038717000000e-02 4.077000000000e-09 4.008418000000e-02 4.077306000000e-09 3.906244000000e-02 4.077515000000e-09 3.826537000000e-02 4.078112000000e-09 3.572660000000e-02 4.079900000000e-09 2.851015000000e-02 4.082540000000e-09 1.954733000000e-02 4.086501000000e-09 1.039415000000e-02 4.092049000000e-09 3.780443000000e-03 4.100074000000e-09 6.745930000000e-04 4.112222000000e-09 -3.133998000000e-05 4.128358000000e-09 2.199832000000e-05 4.151784000000e-09 -4.195500000000e-06 4.181738000000e-09 1.635164000000e-05 4.223091000000e-09 -1.027698000000e-06 4.287381000000e-09 1.497488000000e-05 4.412795000000e-09 -6.572122000000e-07 4.639879000000e-09 1.494979000000e-05 4.989879000000e-09 -1.075888000000e-06 5.339879000000e-09 1.531118000000e-05 5.689879000000e-09 -1.377393000000e-06 6.039879000000e-09 1.560417000000e-05 6.389879000000e-09 -1.678920000000e-06 6.739879000000e-09 1.585967000000e-05 7.000000000000e-09 -1.969037000000e-06)
V_XOR_09 xor_09 0 PWL(0.000000000000e+00 6.995221000000e-06 1.000000000000e-12 6.997984000000e-06 2.000000000000e-12 7.000502000000e-06 5.200000000000e-12 7.006871000000e-06 1.544000000000e-11 7.014253000000e-06 4.820800000000e-11 7.014547000000e-06 1.530656000000e-10 7.014629000000e-06 4.886099000000e-10 7.014537000000e-06 8.386099000000e-10 7.014631000000e-06 9.995000000000e-10 7.014537000000e-06 9.996500000000e-10 7.014541000000e-06 1.000130000000e-09 7.014550000000e-06 1.000271000000e-09 7.014553000000e-06 1.000500000000e-09 7.014556000000e-06 1.000549000000e-09 7.014557000000e-06 1.000579000000e-09 7.014557000000e-06 1.000674000000e-09 7.014559000000e-06 1.000921000000e-09 7.014561000000e-06 1.001177000000e-09 7.014564000000e-06 1.001636000000e-09 7.014567000000e-06 1.002995000000e-09 7.014574000000e-06 1.004717000000e-09 7.014578000000e-06 1.007157000000e-09 7.014583000000e-06 1.009530000000e-09 7.014585000000e-06 1.012064000000e-09 7.014586000000e-06 1.014479000000e-09 7.014587000000e-06 1.016999000000e-09 7.014587000000e-06 1.019780000000e-09 7.014587000000e-06 1.023006000000e-09 7.014586000000e-06 1.025715000000e-09 7.014586000000e-06 1.028767000000e-09 7.014585000000e-06 1.031545000000e-09 7.014585000000e-06 1.034548000000e-09 7.014585000000e-06 1.037295000000e-09 7.014585000000e-06 1.040188000000e-09 7.014584000000e-06 1.042931000000e-09 7.014584000000e-06 1.046095000000e-09 7.014584000000e-06 1.049020000000e-09 7.014584000000e-06 1.051920000000e-09 7.014584000000e-06 1.055268000000e-09 7.014584000000e-06 1.057963000000e-09 7.014584000000e-06 1.059420000000e-09 7.014584000000e-06 1.060877000000e-09 7.014584000000e-06 1.063981000000e-09 7.014584000000e-06 1.066813000000e-09 7.014584000000e-06 1.069715000000e-09 7.014584000000e-06 1.073141000000e-09 7.014584000000e-06 1.075000000000e-09 7.014584000000e-06 1.075500000000e-09 -2.045888000000e-02 1.075834000000e-09 -3.391895000000e-02 1.076000000000e-09 -4.043047000000e-02 1.076266000000e-09 -3.910846000000e-02 1.076419000000e-09 -3.826786000000e-02 1.076822000000e-09 -3.580911000000e-02 1.078112000000e-09 -2.860478000000e-02 1.079915000000e-09 -2.077672000000e-02 1.082834000000e-09 -1.253812000000e-02 1.086452000000e-09 -6.732492000000e-03 1.089863000000e-09 -3.811583000000e-03 1.094093000000e-09 -1.921681000000e-03 1.097558000000e-09 -1.165445000000e-03 1.101264000000e-09 -7.065969000000e-04 1.105520000000e-09 -4.344228000000e-04 1.109056000000e-09 -2.959288000000e-04 1.112992000000e-09 -2.150838000000e-04 1.115807000000e-09 -1.673404000000e-04 1.118621000000e-09 -1.279795000000e-04 1.121942000000e-09 -1.058291000000e-04 1.125724000000e-09 -7.572519000000e-05 1.129501000000e-09 -6.325412000000e-05 1.133249000000e-09 -4.285322000000e-05 1.135809000000e-09 -3.586646000000e-05 1.138369000000e-09 -3.451655000000e-05 1.141791000000e-09 -2.258789000000e-05 1.145734000000e-09 -1.990372000000e-05 1.150017000000e-09 -1.043746000000e-05 1.153865000000e-09 -1.130884000000e-05 1.158361000000e-09 -2.231412000000e-06 1.161824000000e-09 4.219210000000e-06 1.165535000000e-09 2.496702000000e-06 1.169527000000e-09 -2.720003000000e-05 1.173109000000e-09 -7.667077000000e-05 1.177056000000e-09 -8.700563000000e-05 1.179535000000e-09 1.218493000000e-04 1.182013000000e-09 4.968333000000e-04 1.185429000000e-09 1.226807000000e-03 1.189651000000e-09 3.851412000000e-04 1.193349000000e-09 -5.130606000000e-03 1.197208000000e-09 -1.697670000000e-02 1.200595000000e-09 -2.226730000000e-02 1.204042000000e-09 4.959910000000e-03 1.207661000000e-09 8.406843000000e-02 1.212044000000e-09 2.033456000000e-01 1.215603000000e-09 2.862736000000e-01 1.219624000000e-09 3.714244000000e-01 1.222280000000e-09 4.314982000000e-01 1.224935000000e-09 4.946305000000e-01 1.228316000000e-09 5.722146000000e-01 1.229186000000e-09 5.900807000000e-01 1.230042000000e-09 6.070960000000e-01 1.232779000000e-09 6.546712000000e-01 1.235670000000e-09 6.939324000000e-01 1.238863000000e-09 7.263783000000e-01 1.243639000000e-09 7.602271000000e-01 1.246999000000e-09 7.781533000000e-01 1.250850000000e-09 7.965329000000e-01 1.255187000000e-09 8.140659000000e-01 1.258822000000e-09 8.254983000000e-01 1.259631000000e-09 8.275790000000e-01 1.260438000000e-09 8.295847000000e-01 1.263021000000e-09 8.351024000000e-01 1.265957000000e-09 8.398937000000e-01 1.269137000000e-09 8.437528000000e-01 1.273131000000e-09 8.474095000000e-01 1.276658000000e-09 8.499060000000e-01 1.280195000000e-09 8.518433000000e-01 1.284359000000e-09 8.534949000000e-01 1.288216000000e-09 8.545564000000e-01 1.291735000000e-09 8.553410000000e-01 1.292574000000e-09 8.555204000000e-01 1.293423000000e-09 8.557015000000e-01 1.296139000000e-09 8.562548000000e-01 1.299136000000e-09 8.568036000000e-01 1.302736000000e-09 8.573728000000e-01 1.306959000000e-09 8.579360000000e-01 1.310392000000e-09 8.583262000000e-01 1.314112000000e-09 8.586867000000e-01 1.317424000000e-09 8.589550000000e-01 1.320972000000e-09 8.591910000000e-01 1.324632000000e-09 8.593849000000e-01 1.327145000000e-09 8.594940000000e-01 1.329658000000e-09 8.595835000000e-01 1.333049000000e-09 8.596811000000e-01 1.337028000000e-09 8.597676000000e-01 1.341293000000e-09 8.598345000000e-01 1.345153000000e-09 8.598777000000e-01 1.349994000000e-09 8.599157000000e-01 1.353616000000e-09 8.599352000000e-01 1.357116000000e-09 8.599493000000e-01 1.357983000000e-09 8.599521000000e-01 1.358962000000e-09 8.599552000000e-01 1.362092000000e-09 8.599633000000e-01 1.364885000000e-09 8.599684000000e-01 1.369987000000e-09 8.599748000000e-01 1.373500000000e-09 8.599778000000e-01 1.377230000000e-09 8.599791000000e-01 1.381288000000e-09 8.599788000000e-01 1.384815000000e-09 8.599801000000e-01 1.388662000000e-09 8.599805000000e-01 1.389532000000e-09 8.599798000000e-01 1.390483000000e-09 8.599786000000e-01 1.393528000000e-09 8.599759000000e-01 1.396267000000e-09 8.599940000000e-01 1.399530000000e-09 8.600528000000e-01 1.403009000000e-09 8.601163000000e-01 1.406745000000e-09 8.601360000000e-01 1.410579000000e-09 8.601168000000e-01 1.413057000000e-09 8.600482000000e-01 1.415535000000e-09 8.599354000000e-01 1.418933000000e-09 8.595651000000e-01 1.419781000000e-09 8.594343000000e-01 1.420563000000e-09 8.593112000000e-01 1.423064000000e-09 8.588945000000e-01 1.426220000000e-09 8.582426000000e-01 1.429627000000e-09 8.570713000000e-01 1.432942000000e-09 8.555521000000e-01 1.436511000000e-09 8.570629000000e-01 1.439973000000e-09 8.659636000000e-01 1.444113000000e-09 8.845486000000e-01 1.447667000000e-09 9.013285000000e-01 1.448597000000e-09 9.048397000000e-01 1.449278000000e-09 9.071876000000e-01 1.451458000000e-09 9.097414000000e-01 1.454984000000e-09 8.821977000000e-01 1.458241000000e-09 8.068658000000e-01 1.461761000000e-09 6.783715000000e-01 1.465886000000e-09 4.983545000000e-01 1.469389000000e-09 3.538359000000e-01 1.472794000000e-09 2.389505000000e-01 1.475276000000e-09 1.737162000000e-01 1.477758000000e-09 1.240849000000e-01 1.479095000000e-09 1.055412000000e-01 1.479882000000e-09 9.537838000000e-02 1.482402000000e-09 6.968386000000e-02 1.485321000000e-09 4.997146000000e-02 1.488790000000e-09 3.576011000000e-02 1.492381000000e-09 2.736944000000e-02 1.496661000000e-09 2.092796000000e-02 1.500576000000e-09 1.599352000000e-02 1.504103000000e-09 1.181990000000e-02 1.508121000000e-09 7.926812000000e-03 1.509046000000e-09 7.210750000000e-03 1.509764000000e-09 6.673379000000e-03 1.512062000000e-09 5.173484000000e-03 1.514727000000e-09 3.821225000000e-03 1.518391000000e-09 2.519142000000e-03 1.521668000000e-09 1.767939000000e-03 1.525243000000e-09 1.239592000000e-03 1.529365000000e-09 8.668617000000e-04 1.532875000000e-09 6.792049000000e-04 1.534025000000e-09 6.362720000000e-04 1.534117000000e-09 -7.301727000000e-04 1.534180000000e-09 -1.680583000000e-03 1.534382000000e-09 -4.454196000000e-03 1.534737000000e-09 -8.482417000000e-03 1.535025000000e-09 -1.081842000000e-02 1.535086000000e-09 -1.038495000000e-02 1.535120000000e-09 -1.013923000000e-02 1.535227000000e-09 -9.391686000000e-03 1.535516000000e-09 -7.552376000000e-03 1.535770000000e-09 -6.130100000000e-03 1.536253000000e-09 -3.808985000000e-03 1.537797000000e-09 1.384226000000e-03 1.540037000000e-09 5.454287000000e-03 1.542991000000e-09 6.379361000000e-03 1.546340000000e-09 4.470390000000e-03 1.549563000000e-09 2.513460000000e-03 1.553023000000e-09 1.120829000000e-03 1.556674000000e-09 3.660896000000e-04 1.561332000000e-09 3.582896000000e-05 1.564959000000e-09 -4.049990000000e-06 1.568637000000e-09 -6.709964000000e-06 1.572862000000e-09 1.741436000000e-07 1.576410000000e-09 1.353969000000e-06 1.580380000000e-09 4.557476000000e-06 1.584817000000e-09 3.886848000000e-06 1.588226000000e-09 5.509266000000e-06 1.592181000000e-09 4.455230000000e-06 1.595925000000e-09 6.172241000000e-06 1.599741000000e-09 5.046688000000e-06 1.604581000000e-09 6.743051000000e-06 1.606342000000e-09 6.350722000000e-06 1.608103000000e-09 5.419887000000e-06 1.611836000000e-09 6.986626000000e-06 1.616035000000e-09 5.545436000000e-06 1.619218000000e-09 7.139721000000e-06 1.623182000000e-09 5.555401000000e-06 1.626358000000e-09 7.163512000000e-06 1.629985000000e-09 5.499890000000e-06 1.634074000000e-09 7.107820000000e-06 1.638238000000e-09 5.426385000000e-06 1.643068000000e-09 7.084477000000e-06 1.648476000000e-09 5.382757000000e-06 1.653917000000e-09 7.095024000000e-06 1.658595000000e-09 5.330893000000e-06 1.665047000000e-09 7.029674000000e-06 1.668427000000e-09 5.241776000000e-06 1.674362000000e-09 6.956341000000e-06 1.678501000000e-09 5.194198000000e-06 1.684581000000e-09 7.002064000000e-06 1.686093000000e-09 6.079753000000e-06 1.687486000000e-09 6.133873000000e-06 1.691945000000e-09 6.202575000000e-06 1.695547000000e-09 6.239690000000e-06 1.700342000000e-09 6.246122000000e-06 1.704014000000e-09 6.261654000000e-06 1.707642000000e-09 6.254108000000e-06 1.712914000000e-09 6.264854000000e-06 1.717024000000e-09 6.255241000000e-06 1.722796000000e-09 6.263931000000e-06 1.724262000000e-09 6.259271000000e-06 1.725743000000e-09 6.258855000000e-06 1.730482000000e-09 6.258399000000e-06 1.734128000000e-09 6.257905000000e-06 1.739613000000e-09 6.257535000000e-06 1.743241000000e-09 6.257105000000e-06 1.746998000000e-09 6.256963000000e-06 1.752400000000e-09 6.256508000000e-06 1.756586000000e-09 6.256431000000e-06 1.762468000000e-09 6.256058000000e-06 1.764025000000e-09 6.256102000000e-06 1.765380000000e-09 6.256010000000e-06 1.769719000000e-09 6.255879000000e-06 1.773264000000e-09 6.255796000000e-06 1.778028000000e-09 6.255684000000e-06 1.781718000000e-09 6.255612000000e-06 1.785310000000e-09 6.255543000000e-06 1.790811000000e-09 6.255459000000e-06 1.794844000000e-09 6.255400000000e-06 1.800637000000e-09 6.255332000000e-06 1.802097000000e-09 6.255337000000e-06 1.803580000000e-09 6.255292000000e-06 1.808326000000e-09 6.255242000000e-06 1.811970000000e-09 6.255223000000e-06 1.817496000000e-09 6.255188000000e-06 1.821120000000e-09 6.255154000000e-06 1.824884000000e-09 6.255128000000e-06 1.830308000000e-09 6.255096000000e-06 1.834495000000e-09 6.255075000000e-06 1.840377000000e-09 6.255045000000e-06 1.841939000000e-09 6.255054000000e-06 1.843284000000e-09 6.255028000000e-06 1.847586000000e-09 6.255006000000e-06 1.851115000000e-09 6.255002000000e-06 1.855851000000e-09 6.254997000000e-06 1.859543000000e-09 6.254967000000e-06 1.863125000000e-09 6.254961000000e-06 1.868621000000e-09 6.254947000000e-06 1.872640000000e-09 6.254935000000e-06 1.878406000000e-09 6.254922000000e-06 1.879857000000e-09 6.254929000000e-06 1.881342000000e-09 6.254911000000e-06 1.886097000000e-09 6.254899000000e-06 1.889729000000e-09 6.254898000000e-06 1.895406000000e-09 6.254887000000e-06 1.899019000000e-09 6.254881000000e-06 1.902802000000e-09 6.254874000000e-06 1.908327000000e-09 6.254864000000e-06 1.912510000000e-09 6.254870000000e-06 1.918396000000e-09 6.254843000000e-06 1.923452000000e-09 6.254843000000e-06 1.928319000000e-09 6.254837000000e-06 1.933832000000e-09 6.254831000000e-06 1.937865000000e-09 6.254828000000e-06 1.941516000000e-09 6.254823000000e-06 1.947123000000e-09 6.254818000000e-06 1.951206000000e-09 6.254814000000e-06 1.957151000000e-09 6.254809000000e-06 1.962202000000e-09 6.254805000000e-06 1.967100000000e-09 6.254802000000e-06 1.968013000000e-09 6.254807000000e-06 1.969099000000e-09 6.254796000000e-06 1.972453000000e-09 6.254797000000e-06 1.975701000000e-09 6.254795000000e-06 1.979195000000e-09 6.254793000000e-06 1.983866000000e-09 6.254790000000e-06 1.987814000000e-09 6.254788000000e-06 1.993099000000e-09 6.254785000000e-06 1.998488000000e-09 6.254782000000e-06 2.003935000000e-09 6.254789000000e-06 2.004866000000e-09 6.254789000000e-06 2.005730000000e-09 6.254777000000e-06 2.008495000000e-09 6.254774000000e-06 2.013208000000e-09 6.254773000000e-06 2.016501000000e-09 6.254767000000e-06 2.021215000000e-09 6.254773000000e-06 2.025252000000e-09 6.254773000000e-06 2.030301000000e-09 6.254768000000e-06 2.035760000000e-09 6.254767000000e-06 2.040977000000e-09 6.254764000000e-06 2.042009000000e-09 6.254768000000e-06 2.042812000000e-09 6.254761000000e-06 2.045379000000e-09 6.254762000000e-06 2.049639000000e-09 6.254761000000e-06 2.053254000000e-09 6.254760000000e-06 2.056728000000e-09 6.254759000000e-06 2.062152000000e-09 6.254758000000e-06 2.066039000000e-09 6.254756000000e-06 2.071558000000e-09 6.254754000000e-06 2.076872000000e-09 6.254755000000e-06 2.078300000000e-09 6.254760000000e-06 2.079144000000e-09 6.254749000000e-06 2.081843000000e-09 6.254752000000e-06 2.085459000000e-09 6.254752000000e-06 2.089564000000e-09 6.254751000000e-06 2.093109000000e-09 6.254750000000e-06 2.096789000000e-09 6.254749000000e-06 2.101106000000e-09 6.254748000000e-06 2.105378000000e-09 6.254747000000e-06 2.110838000000e-09 6.254746000000e-06 2.112251000000e-09 6.254751000000e-06 2.113753000000e-09 6.254740000000e-06 2.118558000000e-09 6.254746000000e-06 2.122133000000e-09 6.254744000000e-06 2.129360000000e-09 6.254743000000e-06 2.132821000000e-09 6.254743000000e-06 2.136929000000e-09 6.254742000000e-06 2.139763000000e-09 6.254742000000e-06 2.142597000000e-09 6.254741000000e-06 2.147012000000e-09 6.254741000000e-06 2.152765000000e-09 6.254740000000e-06 2.154377000000e-09 6.254744000000e-06 2.155442000000e-09 6.254734000000e-06 2.158852000000e-09 6.254739000000e-06 2.162621000000e-09 6.254739000000e-06 2.166944000000e-09 6.254738000000e-06 2.170618000000e-09 6.254750000000e-06 2.174167000000e-09 6.254733000000e-06 2.179170000000e-09 6.254734000000e-06 2.183292000000e-09 6.254735000000e-06 2.188867000000e-09 6.254735000000e-06 2.190278000000e-09 6.254738000000e-06 2.191779000000e-09 6.254731000000e-06 2.196584000000e-09 6.254735000000e-06 2.200169000000e-09 6.254734000000e-06 2.207050000000e-09 6.254734000000e-06 2.210543000000e-09 6.254734000000e-06 2.214570000000e-09 6.254733000000e-06 2.217383000000e-09 6.254733000000e-06 2.220196000000e-09 6.254733000000e-06 2.224548000000e-09 6.254732000000e-06 2.230327000000e-09 6.254732000000e-06 2.231668000000e-09 6.254734000000e-06 2.232487000000e-09 6.254729000000e-06 2.235108000000e-09 6.254731000000e-06 2.238430000000e-09 6.254731000000e-06 2.242101000000e-09 6.254731000000e-06 2.245250000000e-09 6.254731000000e-06 2.248623000000e-09 6.254731000000e-06 2.252399000000e-09 6.254730000000e-06 2.256336000000e-09 6.254730000000e-06 2.261919000000e-09 6.254730000000e-06 2.264384000000e-09 6.254732000000e-06 2.265883000000e-09 6.254730000000e-06 2.270679000000e-09 6.254725000000e-06 2.277378000000e-09 6.254731000000e-06 2.283984000000e-09 6.254728000000e-06 2.291963000000e-09 6.254728000000e-06 2.303337000000e-09 6.254727000000e-06 2.323042000000e-09 6.254727000000e-06 2.352076000000e-09 6.254725000000e-06 2.407975000000e-09 6.254723000000e-06 2.543499000000e-09 6.254721000000e-06 2.778736000000e-09 6.254718000000e-06 3.128736000000e-09 6.254717000000e-06 3.478736000000e-09 6.254717000000e-06 3.828736000000e-09 6.254717000000e-06 4.076000000000e-09 6.254717000000e-06 4.076500000000e-09 2.038748000000e-02 4.077000000000e-09 4.008454000000e-02 4.077306000000e-09 3.906282000000e-02 4.077515000000e-09 3.826576000000e-02 4.078112000000e-09 3.572699000000e-02 4.079900000000e-09 2.851051000000e-02 4.082540000000e-09 1.954759000000e-02 4.086501000000e-09 1.039427000000e-02 4.092049000000e-09 3.780482000000e-03 4.100074000000e-09 6.746006000000e-04 4.112222000000e-09 -3.134145000000e-05 4.128358000000e-09 2.199909000000e-05 4.151784000000e-09 -4.195943000000e-06 4.181738000000e-09 1.635198000000e-05 4.223091000000e-09 -1.027869000000e-06 4.287381000000e-09 1.497511000000e-05 4.412795000000e-09 -6.573154000000e-07 4.639879000000e-09 1.494998000000e-05 4.989879000000e-09 -1.075977000000e-06 5.339879000000e-09 1.531137000000e-05 5.689879000000e-09 -1.377478000000e-06 6.039879000000e-09 1.560436000000e-05 6.389879000000e-09 -1.678998000000e-06 6.739879000000e-09 1.585986000000e-05 7.000000000000e-09 -1.969108000000e-06)
V_XOR_10 xor_10 0 PWL(0.000000000000e+00 6.995221000000e-06 1.000000000000e-12 6.997984000000e-06 2.000000000000e-12 7.000502000000e-06 5.200000000000e-12 7.006871000000e-06 1.544000000000e-11 7.014253000000e-06 4.820800000000e-11 7.014547000000e-06 1.530656000000e-10 7.014629000000e-06 4.886099000000e-10 7.014537000000e-06 8.386099000000e-10 7.014631000000e-06 9.995000000000e-10 7.014537000000e-06 9.996500000000e-10 7.014541000000e-06 1.000130000000e-09 7.014550000000e-06 1.000271000000e-09 7.014553000000e-06 1.000500000000e-09 7.014556000000e-06 1.000549000000e-09 7.014557000000e-06 1.000579000000e-09 7.014557000000e-06 1.000674000000e-09 7.014559000000e-06 1.000921000000e-09 7.014561000000e-06 1.001177000000e-09 7.014564000000e-06 1.001636000000e-09 7.014567000000e-06 1.002995000000e-09 7.014574000000e-06 1.004717000000e-09 7.014578000000e-06 1.007157000000e-09 7.014583000000e-06 1.009530000000e-09 7.014585000000e-06 1.012064000000e-09 7.014586000000e-06 1.014479000000e-09 7.014587000000e-06 1.016999000000e-09 7.014587000000e-06 1.019780000000e-09 7.014587000000e-06 1.023006000000e-09 7.014586000000e-06 1.025715000000e-09 7.014586000000e-06 1.028767000000e-09 7.014585000000e-06 1.031545000000e-09 7.014585000000e-06 1.034548000000e-09 7.014585000000e-06 1.037295000000e-09 7.014585000000e-06 1.040188000000e-09 7.014584000000e-06 1.042931000000e-09 7.014584000000e-06 1.046095000000e-09 7.014584000000e-06 1.049020000000e-09 7.014584000000e-06 1.051920000000e-09 7.014584000000e-06 1.055268000000e-09 7.014584000000e-06 1.057963000000e-09 7.014584000000e-06 1.059420000000e-09 7.014584000000e-06 1.060877000000e-09 7.014584000000e-06 1.063981000000e-09 7.014584000000e-06 1.066813000000e-09 7.014584000000e-06 1.069715000000e-09 7.014584000000e-06 1.073141000000e-09 7.014584000000e-06 1.075000000000e-09 7.014584000000e-06 1.075500000000e-09 -2.045888000000e-02 1.075834000000e-09 -3.391895000000e-02 1.076000000000e-09 -4.043047000000e-02 1.076266000000e-09 -3.910846000000e-02 1.076419000000e-09 -3.826786000000e-02 1.076822000000e-09 -3.580911000000e-02 1.078112000000e-09 -2.860478000000e-02 1.079915000000e-09 -2.077672000000e-02 1.082834000000e-09 -1.253812000000e-02 1.086452000000e-09 -6.732492000000e-03 1.089863000000e-09 -3.811583000000e-03 1.094093000000e-09 -1.921681000000e-03 1.097558000000e-09 -1.165445000000e-03 1.101264000000e-09 -7.065969000000e-04 1.105520000000e-09 -4.344228000000e-04 1.109056000000e-09 -2.959288000000e-04 1.112992000000e-09 -2.150839000000e-04 1.115807000000e-09 -1.673405000000e-04 1.118621000000e-09 -1.279798000000e-04 1.121942000000e-09 -1.058274000000e-04 1.125724000000e-09 -7.572435000000e-05 1.129501000000e-09 -6.325407000000e-05 1.133249000000e-09 -4.285623000000e-05 1.135809000000e-09 -3.587982000000e-05 1.138369000000e-09 -3.454697000000e-05 1.141791000000e-09 -2.267970000000e-05 1.145734000000e-09 -1.970009000000e-05 1.150017000000e-09 -1.008090000000e-05 1.153865000000e-09 -1.102547000000e-05 1.158361000000e-09 -4.724122000000e-06 1.161824000000e-09 -6.095603000000e-06 1.165535000000e-09 -1.569830000000e-06 1.169527000000e-09 -3.298569000000e-06 1.173109000000e-09 4.920070000000e-07 1.177056000000e-09 -5.829516000000e-07 1.179535000000e-09 2.360405000000e-06 1.182013000000e-09 8.095178000000e-06 1.185429000000e-09 1.549260000000e-05 1.189651000000e-09 -6.680330000000e-06 1.193349000000e-09 -5.374739000000e-05 1.197208000000e-09 -1.062724000000e-04 1.200595000000e-09 7.898206000000e-05 1.204042000000e-09 7.267374000000e-04 1.207661000000e-09 1.386929000000e-03 1.212044000000e-09 -7.855077000000e-04 1.215603000000e-09 -7.695816000000e-03 1.219624000000e-09 -2.063963000000e-02 1.222280000000e-09 -1.385894000000e-02 1.224935000000e-09 5.114127000000e-03 1.228316000000e-09 7.203768000000e-02 1.229186000000e-09 9.614531000000e-02 1.230042000000e-09 1.200930000000e-01 1.232779000000e-09 1.946758000000e-01 1.235670000000e-09 2.633956000000e-01 1.238863000000e-09 3.302190000000e-01 1.243639000000e-09 4.366504000000e-01 1.246999000000e-09 5.165967000000e-01 1.250850000000e-09 6.003635000000e-01 1.255187000000e-09 6.730868000000e-01 1.258822000000e-09 7.154693000000e-01 1.259631000000e-09 7.227647000000e-01 1.260438000000e-09 7.297449000000e-01 1.263021000000e-09 7.488969000000e-01 1.265957000000e-09 7.664002000000e-01 1.269137000000e-09 7.828073000000e-01 1.273131000000e-09 8.013154000000e-01 1.276658000000e-09 8.150518000000e-01 1.280195000000e-09 8.259789000000e-01 1.284359000000e-09 8.354806000000e-01 1.288216000000e-09 8.414280000000e-01 1.291735000000e-09 8.452336000000e-01 1.292574000000e-09 8.459779000000e-01 1.293423000000e-09 8.467100000000e-01 1.296139000000e-09 8.487969000000e-01 1.299136000000e-09 8.506844000000e-01 1.302736000000e-09 8.524496000000e-01 1.306959000000e-09 8.539202000000e-01 1.310392000000e-09 8.547789000000e-01 1.314112000000e-09 8.555923000000e-01 1.317424000000e-09 8.562720000000e-01 1.320972000000e-09 8.569139000000e-01 1.324632000000e-09 8.574769000000e-01 1.327145000000e-09 8.578167000000e-01 1.329658000000e-09 8.581184000000e-01 1.333049000000e-09 8.584797000000e-01 1.337028000000e-09 8.588363000000e-01 1.341293000000e-09 8.591415000000e-01 1.345153000000e-09 8.593562000000e-01 1.349994000000e-09 8.595573000000e-01 1.353616000000e-09 8.596672000000e-01 1.357116000000e-09 8.597479000000e-01 1.357983000000e-09 8.597641000000e-01 1.358962000000e-09 8.597817000000e-01 1.362092000000e-09 8.598296000000e-01 1.364885000000e-09 8.598632000000e-01 1.369987000000e-09 8.599079000000e-01 1.373500000000e-09 8.599290000000e-01 1.377230000000e-09 8.599454000000e-01 1.381288000000e-09 8.599581000000e-01 1.384815000000e-09 8.599661000000e-01 1.388662000000e-09 8.599723000000e-01 1.389532000000e-09 8.599734000000e-01 1.390483000000e-09 8.599745000000e-01 1.393528000000e-09 8.599776000000e-01 1.396267000000e-09 8.599800000000e-01 1.399530000000e-09 8.599823000000e-01 1.403009000000e-09 8.599836000000e-01 1.406745000000e-09 8.599842000000e-01 1.410579000000e-09 8.599847000000e-01 1.413057000000e-09 8.599847000000e-01 1.415535000000e-09 8.599844000000e-01 1.418933000000e-09 8.599827000000e-01 1.419781000000e-09 8.599825000000e-01 1.420563000000e-09 8.599824000000e-01 1.423064000000e-09 8.599827000000e-01 1.426220000000e-09 8.599828000000e-01 1.429627000000e-09 8.599794000000e-01 1.432942000000e-09 8.599783000000e-01 1.436511000000e-09 8.600159000000e-01 1.439973000000e-09 8.600860000000e-01 1.444113000000e-09 8.601353000000e-01 1.447667000000e-09 8.601296000000e-01 1.448597000000e-09 8.601243000000e-01 1.449278000000e-09 8.601194000000e-01 1.451458000000e-09 8.600848000000e-01 1.454984000000e-09 8.598821000000e-01 1.458241000000e-09 8.594743000000e-01 1.461761000000e-09 8.588984000000e-01 1.465886000000e-09 8.579927000000e-01 1.469389000000e-09 8.566196000000e-01 1.472794000000e-09 8.553983000000e-01 1.475276000000e-09 8.575952000000e-01 1.477758000000e-09 8.623951000000e-01 1.479095000000e-09 8.674562000000e-01 1.479882000000e-09 8.706415000000e-01 1.482402000000e-09 8.822658000000e-01 1.485321000000e-09 8.963148000000e-01 1.488790000000e-09 9.082427000000e-01 1.492381000000e-09 8.970759000000e-01 1.496661000000e-09 8.154907000000e-01 1.500576000000e-09 6.745125000000e-01 1.504103000000e-09 5.200533000000e-01 1.508121000000e-09 3.534693000000e-01 1.509046000000e-09 3.203487000000e-01 1.509764000000e-09 2.952029000000e-01 1.512062000000e-09 2.225035000000e-01 1.514727000000e-09 1.557647000000e-01 1.518391000000e-09 9.574616000000e-02 1.521668000000e-09 6.391918000000e-02 1.525243000000e-09 4.329938000000e-02 1.529365000000e-09 3.036739000000e-02 1.532875000000e-09 2.419462000000e-02 1.534025000000e-09 2.262238000000e-02 1.534117000000e-09 2.140300000000e-02 1.534180000000e-09 2.060451000000e-02 1.534382000000e-09 1.831714000000e-02 1.534737000000e-09 1.477354000000e-02 1.535025000000e-09 1.255194000000e-02 1.535086000000e-09 1.287474000000e-02 1.535120000000e-09 1.305426000000e-02 1.535227000000e-09 1.356774000000e-02 1.535516000000e-09 1.479411000000e-02 1.535770000000e-09 1.571686000000e-02 1.536253000000e-09 1.715889000000e-02 1.537797000000e-09 2.014446000000e-02 1.540037000000e-09 2.151001000000e-02 1.542991000000e-09 1.893138000000e-02 1.546340000000e-09 1.316597000000e-02 1.549563000000e-09 8.165845000000e-03 1.553023000000e-09 4.528479000000e-03 1.556674000000e-09 2.330150000000e-03 1.561332000000e-09 9.853183000000e-04 1.564959000000e-09 5.327754000000e-04 1.568637000000e-09 2.921950000000e-04 1.572862000000e-09 1.511533000000e-04 1.576410000000e-09 8.918529000000e-05 1.580380000000e-09 5.216881000000e-05 1.584817000000e-09 2.792430000000e-05 1.588226000000e-09 1.953974000000e-05 1.592181000000e-09 1.202537000000e-05 1.595925000000e-09 1.010238000000e-05 1.599741000000e-09 7.312395000000e-06 1.604581000000e-09 7.527610000000e-06 1.606342000000e-09 6.912751000000e-06 1.608103000000e-09 5.928112000000e-06 1.611836000000e-09 7.034622000000e-06 1.616035000000e-09 5.699104000000e-06 1.619218000000e-09 6.946873000000e-06 1.623182000000e-09 5.620508000000e-06 1.626358000000e-09 6.947227000000e-06 1.629985000000e-09 5.599839000000e-06 1.634074000000e-09 6.976813000000e-06 1.638238000000e-09 5.591349000000e-06 1.643068000000e-09 6.990806000000e-06 1.648476000000e-09 5.575824000000e-06 1.653917000000e-09 6.996481000000e-06 1.658595000000e-09 5.564817000000e-06 1.665047000000e-09 7.003043000000e-06 1.668427000000e-09 5.554855000000e-06 1.674362000000e-09 7.012500000000e-06 1.678501000000e-09 5.546713000000e-06 1.684581000000e-09 7.017060000000e-06 1.686093000000e-09 6.277023000000e-06 1.687486000000e-09 6.277858000000e-06 1.691945000000e-09 6.267075000000e-06 1.695547000000e-09 6.269841000000e-06 1.700342000000e-09 6.262227000000e-06 1.704014000000e-09 6.266955000000e-06 1.707642000000e-09 6.261534000000e-06 1.712914000000e-09 6.266131000000e-06 1.717024000000e-09 6.261350000000e-06 1.722796000000e-09 6.265807000000e-06 1.724262000000e-09 6.263647000000e-06 1.725743000000e-09 6.263512000000e-06 1.730482000000e-09 6.263624000000e-06 1.734128000000e-09 6.263499000000e-06 1.739613000000e-09 6.263629000000e-06 1.743241000000e-09 6.263526000000e-06 1.746998000000e-09 6.263630000000e-06 1.752400000000e-09 6.263540000000e-06 1.756586000000e-09 6.263638000000e-06 1.762468000000e-09 6.263553000000e-06 1.764025000000e-09 6.263597000000e-06 1.765380000000e-09 6.263600000000e-06 1.769719000000e-09 6.263614000000e-06 1.773264000000e-09 6.263604000000e-06 1.778028000000e-09 6.263603000000e-06 1.781718000000e-09 6.263610000000e-06 1.785310000000e-09 6.263612000000e-06 1.790811000000e-09 6.263617000000e-06 1.794844000000e-09 6.263617000000e-06 1.800637000000e-09 6.263621000000e-06 1.802097000000e-09 6.263620000000e-06 1.803580000000e-09 6.263620000000e-06 1.808326000000e-09 6.263623000000e-06 1.811970000000e-09 6.263625000000e-06 1.817496000000e-09 6.263625000000e-06 1.821120000000e-09 6.263626000000e-06 1.824884000000e-09 6.263627000000e-06 1.830308000000e-09 6.263626000000e-06 1.834495000000e-09 6.263629000000e-06 1.840377000000e-09 6.263630000000e-06 1.841939000000e-09 6.263630000000e-06 1.843284000000e-09 6.263629000000e-06 1.847586000000e-09 6.263631000000e-06 1.851115000000e-09 6.263631000000e-06 1.855851000000e-09 6.263632000000e-06 1.859543000000e-09 6.263632000000e-06 1.863125000000e-09 6.263632000000e-06 1.868621000000e-09 6.263633000000e-06 1.872640000000e-09 6.263633000000e-06 1.878406000000e-09 6.263634000000e-06 1.879857000000e-09 6.263634000000e-06 1.881342000000e-09 6.263634000000e-06 1.886097000000e-09 6.263635000000e-06 1.889729000000e-09 6.263635000000e-06 1.895406000000e-09 6.263635000000e-06 1.899019000000e-09 6.263635000000e-06 1.902802000000e-09 6.263636000000e-06 1.908327000000e-09 6.263636000000e-06 1.912510000000e-09 6.263636000000e-06 1.918396000000e-09 6.263636000000e-06 1.923452000000e-09 6.263637000000e-06 1.928319000000e-09 6.263637000000e-06 1.933832000000e-09 6.263637000000e-06 1.937865000000e-09 6.263637000000e-06 1.941516000000e-09 6.263637000000e-06 1.947123000000e-09 6.263637000000e-06 1.951206000000e-09 6.263638000000e-06 1.957151000000e-09 6.263638000000e-06 1.962202000000e-09 6.263638000000e-06 1.967100000000e-09 6.263638000000e-06 1.968013000000e-09 6.263638000000e-06 1.969099000000e-09 6.263638000000e-06 1.972453000000e-09 6.263638000000e-06 1.975701000000e-09 6.263638000000e-06 1.979195000000e-09 6.263638000000e-06 1.983866000000e-09 6.263638000000e-06 1.987814000000e-09 6.263638000000e-06 1.993099000000e-09 6.263639000000e-06 1.998488000000e-09 6.263639000000e-06 2.003935000000e-09 6.263639000000e-06 2.004866000000e-09 6.263639000000e-06 2.005730000000e-09 6.263639000000e-06 2.008495000000e-09 6.263639000000e-06 2.013208000000e-09 6.263639000000e-06 2.016501000000e-09 6.263639000000e-06 2.021215000000e-09 6.263639000000e-06 2.025252000000e-09 6.263639000000e-06 2.030301000000e-09 6.263639000000e-06 2.035760000000e-09 6.263639000000e-06 2.040977000000e-09 6.263640000000e-06 2.042009000000e-09 6.263642000000e-06 2.042812000000e-09 6.263644000000e-06 2.045379000000e-09 6.263644000000e-06 2.049639000000e-09 6.263636000000e-06 2.053254000000e-09 6.263635000000e-06 2.056728000000e-09 6.263637000000e-06 2.062152000000e-09 6.263639000000e-06 2.066039000000e-09 6.263640000000e-06 2.071558000000e-09 6.263640000000e-06 2.076872000000e-09 6.263640000000e-06 2.078300000000e-09 6.263640000000e-06 2.079144000000e-09 6.263640000000e-06 2.081843000000e-09 6.263640000000e-06 2.085459000000e-09 6.263640000000e-06 2.089564000000e-09 6.263640000000e-06 2.093109000000e-09 6.263640000000e-06 2.096789000000e-09 6.263640000000e-06 2.101106000000e-09 6.263640000000e-06 2.105378000000e-09 6.263640000000e-06 2.110838000000e-09 6.263640000000e-06 2.112251000000e-09 6.263640000000e-06 2.113753000000e-09 6.263640000000e-06 2.118558000000e-09 6.263640000000e-06 2.122133000000e-09 6.263640000000e-06 2.129360000000e-09 6.263640000000e-06 2.132821000000e-09 6.263640000000e-06 2.136929000000e-09 6.263640000000e-06 2.139763000000e-09 6.263640000000e-06 2.142597000000e-09 6.263640000000e-06 2.147012000000e-09 6.263640000000e-06 2.152765000000e-09 6.263640000000e-06 2.154377000000e-09 6.263640000000e-06 2.155442000000e-09 6.263640000000e-06 2.158852000000e-09 6.263640000000e-06 2.162621000000e-09 6.263640000000e-06 2.166944000000e-09 6.263640000000e-06 2.170618000000e-09 6.263640000000e-06 2.174167000000e-09 6.263640000000e-06 2.179170000000e-09 6.263640000000e-06 2.183292000000e-09 6.263640000000e-06 2.188867000000e-09 6.263640000000e-06 2.190278000000e-09 6.263640000000e-06 2.191779000000e-09 6.263640000000e-06 2.196584000000e-09 6.263640000000e-06 2.200169000000e-09 6.263641000000e-06 2.207050000000e-09 6.263639000000e-06 2.210543000000e-09 6.263641000000e-06 2.214570000000e-09 6.263641000000e-06 2.217383000000e-09 6.263640000000e-06 2.220196000000e-09 6.263640000000e-06 2.224548000000e-09 6.263640000000e-06 2.230327000000e-09 6.263640000000e-06 2.231668000000e-09 6.263640000000e-06 2.232487000000e-09 6.263640000000e-06 2.235108000000e-09 6.263640000000e-06 2.238430000000e-09 6.263640000000e-06 2.242101000000e-09 6.263640000000e-06 2.245250000000e-09 6.263640000000e-06 2.248623000000e-09 6.263640000000e-06 2.252399000000e-09 6.263640000000e-06 2.256336000000e-09 6.263640000000e-06 2.261919000000e-09 6.263640000000e-06 2.264384000000e-09 6.263640000000e-06 2.265883000000e-09 6.263640000000e-06 2.270679000000e-09 6.263640000000e-06 2.277378000000e-09 6.263641000000e-06 2.283984000000e-09 6.263640000000e-06 2.291963000000e-09 6.263640000000e-06 2.303337000000e-09 6.263641000000e-06 2.323042000000e-09 6.263641000000e-06 2.352076000000e-09 6.263641000000e-06 2.407975000000e-09 6.263641000000e-06 2.543499000000e-09 6.263641000000e-06 2.778736000000e-09 6.263641000000e-06 3.128736000000e-09 6.263641000000e-06 3.478736000000e-09 6.263641000000e-06 3.828736000000e-09 6.263641000000e-06 4.076000000000e-09 6.263641000000e-06 4.076500000000e-09 2.037595000000e-02 4.077000000000e-09 4.006697000000e-02 4.077306000000e-09 3.904522000000e-02 4.077515000000e-09 3.824784000000e-02 4.078112000000e-09 3.570850000000e-02 4.079900000000e-09 2.849797000000e-02 4.082540000000e-09 1.954969000000e-02 4.086501000000e-09 1.040365000000e-02 4.092049000000e-09 3.783104000000e-03 4.100074000000e-09 6.728196000000e-04 4.112222000000e-09 -3.187522000000e-05 4.128358000000e-09 2.202136000000e-05 4.151784000000e-09 -4.242772000000e-06 4.181738000000e-09 1.638191000000e-05 4.223091000000e-09 -1.068432000000e-06 4.287381000000e-09 1.500029000000e-05 4.412795000000e-09 -6.961011000000e-07 4.639879000000e-09 1.497462000000e-05 4.989879000000e-09 -1.114522000000e-06 5.339879000000e-09 1.533508000000e-05 5.689879000000e-09 -1.415366000000e-06 6.039879000000e-09 1.562723000000e-05 6.389879000000e-09 -1.716464000000e-06 6.739879000000e-09 1.588196000000e-05 7.000000000000e-09 -2.006151000000e-06)
V_XOR_11 xor_11 0 PWL(0.000000000000e+00 6.995221000000e-06 1.000000000000e-12 6.997984000000e-06 2.000000000000e-12 7.000502000000e-06 5.200000000000e-12 7.006871000000e-06 1.544000000000e-11 7.014253000000e-06 4.820800000000e-11 7.014547000000e-06 1.530656000000e-10 7.014629000000e-06 4.886099000000e-10 7.014537000000e-06 8.386099000000e-10 7.014631000000e-06 9.995000000000e-10 7.014537000000e-06 9.996500000000e-10 7.014541000000e-06 1.000130000000e-09 7.014550000000e-06 1.000271000000e-09 7.014553000000e-06 1.000500000000e-09 7.014556000000e-06 1.000549000000e-09 7.014557000000e-06 1.000579000000e-09 7.014557000000e-06 1.000674000000e-09 7.014559000000e-06 1.000921000000e-09 7.014561000000e-06 1.001177000000e-09 7.014564000000e-06 1.001636000000e-09 7.014567000000e-06 1.002995000000e-09 7.014574000000e-06 1.004717000000e-09 7.014578000000e-06 1.007157000000e-09 7.014583000000e-06 1.009530000000e-09 7.014585000000e-06 1.012064000000e-09 7.014586000000e-06 1.014479000000e-09 7.014587000000e-06 1.016999000000e-09 7.014587000000e-06 1.019780000000e-09 7.014587000000e-06 1.023006000000e-09 7.014586000000e-06 1.025715000000e-09 7.014586000000e-06 1.028767000000e-09 7.014585000000e-06 1.031545000000e-09 7.014585000000e-06 1.034548000000e-09 7.014585000000e-06 1.037295000000e-09 7.014585000000e-06 1.040188000000e-09 7.014584000000e-06 1.042931000000e-09 7.014584000000e-06 1.046095000000e-09 7.014584000000e-06 1.049020000000e-09 7.014584000000e-06 1.051920000000e-09 7.014584000000e-06 1.055268000000e-09 7.014584000000e-06 1.057963000000e-09 7.014584000000e-06 1.059420000000e-09 7.014584000000e-06 1.060877000000e-09 7.014584000000e-06 1.063981000000e-09 7.014584000000e-06 1.066813000000e-09 7.014584000000e-06 1.069715000000e-09 7.014584000000e-06 1.073141000000e-09 7.014584000000e-06 1.075000000000e-09 7.014584000000e-06 1.075500000000e-09 -2.045888000000e-02 1.075834000000e-09 -3.391895000000e-02 1.076000000000e-09 -4.043047000000e-02 1.076266000000e-09 -3.910846000000e-02 1.076419000000e-09 -3.826786000000e-02 1.076822000000e-09 -3.580911000000e-02 1.078112000000e-09 -2.860478000000e-02 1.079915000000e-09 -2.077672000000e-02 1.082834000000e-09 -1.253812000000e-02 1.086452000000e-09 -6.732492000000e-03 1.089863000000e-09 -3.811583000000e-03 1.094093000000e-09 -1.921681000000e-03 1.097558000000e-09 -1.165445000000e-03 1.101264000000e-09 -7.065969000000e-04 1.105520000000e-09 -4.344228000000e-04 1.109056000000e-09 -2.959288000000e-04 1.112992000000e-09 -2.150839000000e-04 1.115807000000e-09 -1.673405000000e-04 1.118621000000e-09 -1.279798000000e-04 1.121942000000e-09 -1.058274000000e-04 1.125724000000e-09 -7.572437000000e-05 1.129501000000e-09 -6.325407000000e-05 1.133249000000e-09 -4.285625000000e-05 1.135809000000e-09 -3.587991000000e-05 1.138369000000e-09 -3.454716000000e-05 1.141791000000e-09 -2.268020000000e-05 1.145734000000e-09 -1.969643000000e-05 1.150017000000e-09 -1.008206000000e-05 1.153865000000e-09 -1.102571000000e-05 1.158361000000e-09 -4.749245000000e-06 1.161824000000e-09 -6.267905000000e-06 1.165535000000e-09 -1.368404000000e-06 1.169527000000e-09 -3.001487000000e-06 1.173109000000e-09 8.405107000000e-07 1.177056000000e-09 -9.343576000000e-07 1.179535000000e-09 1.720648000000e-07 1.182013000000e-09 2.991847000000e-06 1.185429000000e-09 9.935224000000e-07 1.189651000000e-09 3.398477000000e-06 1.193349000000e-09 1.968185000000e-06 1.197208000000e-09 4.126649000000e-06 1.200595000000e-09 5.453042000000e-06 1.204042000000e-09 2.447358000000e-05 1.207661000000e-09 -3.115394000000e-06 1.212044000000e-09 -2.691279000000e-05 1.215603000000e-09 -8.538584000000e-05 1.219624000000e-09 -9.158138000000e-05 1.222280000000e-09 1.397160000000e-04 1.224935000000e-09 5.582486000000e-04 1.228316000000e-09 1.270904000000e-03 1.229186000000e-09 1.363671000000e-03 1.230042000000e-09 1.406592000000e-03 1.232779000000e-09 7.123961000000e-05 1.235670000000e-09 -4.642897000000e-03 1.238863000000e-09 -1.376145000000e-02 1.243639000000e-09 -1.679625000000e-02 1.246999000000e-09 1.475012000000e-02 1.250850000000e-09 1.027645000000e-01 1.255187000000e-09 2.192036000000e-01 1.258822000000e-09 3.010161000000e-01 1.259631000000e-09 3.173264000000e-01 1.260438000000e-09 3.338925000000e-01 1.263021000000e-09 3.903281000000e-01 1.265957000000e-09 4.589837000000e-01 1.269137000000e-09 5.337406000000e-01 1.273131000000e-09 6.171480000000e-01 1.276658000000e-09 6.739819000000e-01 1.280195000000e-09 7.151646000000e-01 1.284359000000e-09 7.487925000000e-01 1.288216000000e-09 7.712859000000e-01 1.291735000000e-09 7.887456000000e-01 1.292574000000e-09 7.926244000000e-01 1.293423000000e-09 7.964910000000e-01 1.296139000000e-09 8.078829000000e-01 1.299136000000e-09 8.185808000000e-01 1.302736000000e-09 8.288635000000e-01 1.306959000000e-09 8.375462000000e-01 1.310392000000e-09 8.423286000000e-01 1.314112000000e-09 8.460960000000e-01 1.317424000000e-09 8.487133000000e-01 1.320972000000e-09 8.509312000000e-01 1.324632000000e-09 8.526606000000e-01 1.327145000000e-09 8.535822000000e-01 1.329658000000e-09 8.542875000000e-01 1.333049000000e-09 8.550700000000e-01 1.337028000000e-09 8.559146000000e-01 1.341293000000e-09 8.567323000000e-01 1.345153000000e-09 8.573527000000e-01 1.349994000000e-09 8.579952000000e-01 1.353616000000e-09 8.583969000000e-01 1.357116000000e-09 8.587269000000e-01 1.357983000000e-09 8.587985000000e-01 1.358962000000e-09 8.588770000000e-01 1.362092000000e-09 8.591009000000e-01 1.364885000000e-09 8.592676000000e-01 1.369987000000e-09 8.595039000000e-01 1.373500000000e-09 8.596230000000e-01 1.377230000000e-09 8.597193000000e-01 1.381288000000e-09 8.597968000000e-01 1.384815000000e-09 8.598463000000e-01 1.388662000000e-09 8.598862000000e-01 1.389532000000e-09 8.598932000000e-01 1.390483000000e-09 8.599007000000e-01 1.393528000000e-09 8.599209000000e-01 1.396267000000e-09 8.599351000000e-01 1.399530000000e-09 8.599482000000e-01 1.403009000000e-09 8.599586000000e-01 1.406745000000e-09 8.599668000000e-01 1.410579000000e-09 8.599728000000e-01 1.413057000000e-09 8.599758000000e-01 1.415535000000e-09 8.599781000000e-01 1.418933000000e-09 8.599805000000e-01 1.419781000000e-09 8.599810000000e-01 1.420563000000e-09 8.599814000000e-01 1.423064000000e-09 8.599826000000e-01 1.426220000000e-09 8.599838000000e-01 1.429627000000e-09 8.599847000000e-01 1.432942000000e-09 8.599854000000e-01 1.436511000000e-09 8.599863000000e-01 1.439973000000e-09 8.599869000000e-01 1.444113000000e-09 8.599867000000e-01 1.447667000000e-09 8.599863000000e-01 1.448597000000e-09 8.599864000000e-01 1.449278000000e-09 8.599864000000e-01 1.451458000000e-09 8.599862000000e-01 1.454984000000e-09 8.599849000000e-01 1.458241000000e-09 8.599831000000e-01 1.461761000000e-09 8.599831000000e-01 1.465886000000e-09 8.599829000000e-01 1.469389000000e-09 8.599785000000e-01 1.472794000000e-09 8.599836000000e-01 1.475276000000e-09 8.600113000000e-01 1.477758000000e-09 8.600592000000e-01 1.479095000000e-09 8.600838000000e-01 1.479882000000e-09 8.600980000000e-01 1.482402000000e-09 8.601270000000e-01 1.485321000000e-09 8.601318000000e-01 1.488790000000e-09 8.601111000000e-01 1.492381000000e-09 8.599879000000e-01 1.496661000000e-09 8.595327000000e-01 1.500576000000e-09 8.588826000000e-01 1.504103000000e-09 8.581352000000e-01 1.508121000000e-09 8.565983000000e-01 1.509046000000e-09 8.560955000000e-01 1.509764000000e-09 8.557172000000e-01 1.512062000000e-09 8.552717000000e-01 1.514727000000e-09 8.579489000000e-01 1.518391000000e-09 8.694127000000e-01 1.521668000000e-09 8.849188000000e-01 1.525243000000e-09 9.016907000000e-01 1.529365000000e-09 9.073361000000e-01 1.532875000000e-09 8.754022000000e-01 1.534025000000e-09 8.525789000000e-01 1.534117000000e-09 8.481125000000e-01 1.534180000000e-09 8.451291000000e-01 1.534382000000e-09 8.360393000000e-01 1.534737000000e-09 8.212191000000e-01 1.535025000000e-09 8.110397000000e-01 1.535086000000e-09 8.098900000000e-01 1.535120000000e-09 8.092844000000e-01 1.535227000000e-09 8.072235000000e-01 1.535516000000e-09 8.009655000000e-01 1.535770000000e-09 7.949368000000e-01 1.536253000000e-09 7.821356000000e-01 1.537797000000e-09 7.325555000000e-01 1.540037000000e-09 6.445855000000e-01 1.542991000000e-09 5.145989000000e-01 1.546340000000e-09 3.739446000000e-01 1.549563000000e-09 2.627964000000e-01 1.553023000000e-09 1.729704000000e-01 1.556674000000e-09 1.135667000000e-01 1.561332000000e-09 7.084076000000e-02 1.564959000000e-09 5.095465000000e-02 1.568637000000e-09 3.665761000000e-02 1.572862000000e-09 2.330439000000e-02 1.576410000000e-09 1.462169000000e-02 1.580380000000e-09 8.175065000000e-03 1.584817000000e-09 4.103661000000e-03 1.588226000000e-09 2.412480000000e-03 1.592181000000e-09 1.291148000000e-03 1.595925000000e-09 7.128631000000e-04 1.599741000000e-09 3.966644000000e-04 1.604581000000e-09 1.853431000000e-04 1.606342000000e-09 1.404782000000e-04 1.608103000000e-09 1.126891000000e-04 1.611836000000e-09 6.106281000000e-05 1.616035000000e-09 4.164768000000e-05 1.619218000000e-09 2.670487000000e-05 1.623182000000e-09 1.944129000000e-05 1.626358000000e-09 1.290844000000e-05 1.629985000000e-09 8.741541000000e-06 1.634074000000e-09 6.016477000000e-06 1.638238000000e-09 5.209784000000e-06 1.643068000000e-09 4.267361000000e-06 1.648476000000e-09 4.501791000000e-06 1.653917000000e-09 4.050576000000e-06 1.658595000000e-09 4.746718000000e-06 1.665047000000e-09 3.938466000000e-06 1.668427000000e-09 5.057198000000e-06 1.674362000000e-09 3.391226000000e-06 1.678501000000e-09 5.114661000000e-06 1.684581000000e-09 3.697277000000e-06 1.686093000000e-09 5.352047000000e-06 1.687486000000e-09 4.746003000000e-06 1.691945000000e-09 5.635853000000e-06 1.695547000000e-09 5.964390000000e-06 1.700342000000e-09 6.120705000000e-06 1.704014000000e-09 6.172490000000e-06 1.707642000000e-09 6.212193000000e-06 1.712914000000e-09 6.229219000000e-06 1.717024000000e-09 6.243090000000e-06 1.722796000000e-09 6.242820000000e-06 1.724262000000e-09 6.246142000000e-06 1.725743000000e-09 6.246508000000e-06 1.730482000000e-09 6.247088000000e-06 1.734128000000e-09 6.246710000000e-06 1.739613000000e-09 6.246600000000e-06 1.743241000000e-09 6.247002000000e-06 1.746998000000e-09 6.246728000000e-06 1.752400000000e-09 6.247067000000e-06 1.756586000000e-09 6.246785000000e-06 1.762468000000e-09 6.247082000000e-06 1.764025000000e-09 6.246947000000e-06 1.765380000000e-09 6.246940000000e-06 1.769719000000e-09 6.246953000000e-06 1.773264000000e-09 6.246948000000e-06 1.778028000000e-09 6.246958000000e-06 1.781718000000e-09 6.246952000000e-06 1.785310000000e-09 6.246960000000e-06 1.790811000000e-09 6.246956000000e-06 1.794844000000e-09 6.246963000000e-06 1.800637000000e-09 6.246959000000e-06 1.802097000000e-09 6.246962000000e-06 1.803580000000e-09 6.246962000000e-06 1.808326000000e-09 6.246978000000e-06 1.811970000000e-09 6.246959000000e-06 1.817496000000e-09 6.246958000000e-06 1.821120000000e-09 6.246969000000e-06 1.824884000000e-09 6.246966000000e-06 1.830308000000e-09 6.246964000000e-06 1.834495000000e-09 6.246968000000e-06 1.840377000000e-09 6.246970000000e-06 1.841939000000e-09 6.246970000000e-06 1.843284000000e-09 6.246970000000e-06 1.847586000000e-09 6.246971000000e-06 1.851115000000e-09 6.246971000000e-06 1.855851000000e-09 6.246972000000e-06 1.859543000000e-09 6.246972000000e-06 1.863125000000e-09 6.246972000000e-06 1.868621000000e-09 6.246972000000e-06 1.872640000000e-09 6.246972000000e-06 1.878406000000e-09 6.246973000000e-06 1.879857000000e-09 6.246973000000e-06 1.881342000000e-09 6.246973000000e-06 1.886097000000e-09 6.246973000000e-06 1.889729000000e-09 6.246974000000e-06 1.895406000000e-09 6.246974000000e-06 1.899019000000e-09 6.246973000000e-06 1.902802000000e-09 6.246974000000e-06 1.908327000000e-09 6.246975000000e-06 1.912510000000e-09 6.246975000000e-06 1.918396000000e-09 6.246975000000e-06 1.923452000000e-09 6.246975000000e-06 1.928319000000e-09 6.246975000000e-06 1.933832000000e-09 6.246975000000e-06 1.937865000000e-09 6.246976000000e-06 1.941516000000e-09 6.246976000000e-06 1.947123000000e-09 6.246976000000e-06 1.951206000000e-09 6.246976000000e-06 1.957151000000e-09 6.246976000000e-06 1.962202000000e-09 6.246976000000e-06 1.967100000000e-09 6.246976000000e-06 1.968013000000e-09 6.246976000000e-06 1.969099000000e-09 6.246976000000e-06 1.972453000000e-09 6.246976000000e-06 1.975701000000e-09 6.246976000000e-06 1.979195000000e-09 6.246977000000e-06 1.983866000000e-09 6.246977000000e-06 1.987814000000e-09 6.246977000000e-06 1.993099000000e-09 6.246977000000e-06 1.998488000000e-09 6.246977000000e-06 2.003935000000e-09 6.246977000000e-06 2.004866000000e-09 6.246977000000e-06 2.005730000000e-09 6.246977000000e-06 2.008495000000e-09 6.246977000000e-06 2.013208000000e-09 6.246977000000e-06 2.016501000000e-09 6.246977000000e-06 2.021215000000e-09 6.246977000000e-06 2.025252000000e-09 6.246977000000e-06 2.030301000000e-09 6.246977000000e-06 2.035760000000e-09 6.246977000000e-06 2.040977000000e-09 6.246977000000e-06 2.042009000000e-09 6.246977000000e-06 2.042812000000e-09 6.246977000000e-06 2.045379000000e-09 6.246977000000e-06 2.049639000000e-09 6.246977000000e-06 2.053254000000e-09 6.246978000000e-06 2.056728000000e-09 6.246978000000e-06 2.062152000000e-09 6.246978000000e-06 2.066039000000e-09 6.246978000000e-06 2.071558000000e-09 6.246978000000e-06 2.076872000000e-09 6.246978000000e-06 2.078300000000e-09 6.246978000000e-06 2.079144000000e-09 6.246978000000e-06 2.081843000000e-09 6.246978000000e-06 2.085459000000e-09 6.246978000000e-06 2.089564000000e-09 6.246978000000e-06 2.093109000000e-09 6.246978000000e-06 2.096789000000e-09 6.246978000000e-06 2.101106000000e-09 6.246978000000e-06 2.105378000000e-09 6.246978000000e-06 2.110838000000e-09 6.246978000000e-06 2.112251000000e-09 6.246978000000e-06 2.113753000000e-09 6.246978000000e-06 2.118558000000e-09 6.246978000000e-06 2.122133000000e-09 6.246978000000e-06 2.129360000000e-09 6.246978000000e-06 2.132821000000e-09 6.246978000000e-06 2.136929000000e-09 6.246978000000e-06 2.139763000000e-09 6.246978000000e-06 2.142597000000e-09 6.246978000000e-06 2.147012000000e-09 6.246978000000e-06 2.152765000000e-09 6.246978000000e-06 2.154377000000e-09 6.246978000000e-06 2.155442000000e-09 6.246978000000e-06 2.158852000000e-09 6.246978000000e-06 2.162621000000e-09 6.246978000000e-06 2.166944000000e-09 6.246978000000e-06 2.170618000000e-09 6.246978000000e-06 2.174167000000e-09 6.246978000000e-06 2.179170000000e-09 6.246978000000e-06 2.183292000000e-09 6.246978000000e-06 2.188867000000e-09 6.246978000000e-06 2.190278000000e-09 6.246978000000e-06 2.191779000000e-09 6.246978000000e-06 2.196584000000e-09 6.246978000000e-06 2.200169000000e-09 6.246978000000e-06 2.207050000000e-09 6.246978000000e-06 2.210543000000e-09 6.246978000000e-06 2.214570000000e-09 6.246978000000e-06 2.217383000000e-09 6.246978000000e-06 2.220196000000e-09 6.246978000000e-06 2.224548000000e-09 6.246978000000e-06 2.230327000000e-09 6.246978000000e-06 2.231668000000e-09 6.246978000000e-06 2.232487000000e-09 6.246978000000e-06 2.235108000000e-09 6.246978000000e-06 2.238430000000e-09 6.246978000000e-06 2.242101000000e-09 6.246978000000e-06 2.245250000000e-09 6.246978000000e-06 2.248623000000e-09 6.246978000000e-06 2.252399000000e-09 6.246978000000e-06 2.256336000000e-09 6.246978000000e-06 2.261919000000e-09 6.246978000000e-06 2.264384000000e-09 6.246978000000e-06 2.265883000000e-09 6.246978000000e-06 2.270679000000e-09 6.246978000000e-06 2.277378000000e-09 6.246979000000e-06 2.283984000000e-09 6.246978000000e-06 2.291963000000e-09 6.246978000000e-06 2.303337000000e-09 6.246978000000e-06 2.323042000000e-09 6.246979000000e-06 2.352076000000e-09 6.246979000000e-06 2.407975000000e-09 6.246979000000e-06 2.543499000000e-09 6.246979000000e-06 2.778736000000e-09 6.246979000000e-06 3.128736000000e-09 6.246979000000e-06 3.478736000000e-09 6.246979000000e-06 3.828736000000e-09 6.246979000000e-06 4.076000000000e-09 6.246979000000e-06 4.076500000000e-09 2.040519000000e-02 4.077000000000e-09 4.009342000000e-02 4.077306000000e-09 3.907014000000e-02 4.077515000000e-09 3.827178000000e-02 4.078112000000e-09 3.572981000000e-02 4.079900000000e-09 2.851293000000e-02 4.082540000000e-09 1.955858000000e-02 4.086501000000e-09 1.040770000000e-02 4.092049000000e-09 3.784395000000e-03 4.100074000000e-09 6.730046000000e-04 4.112222000000e-09 -3.188346000000e-05 4.128358000000e-09 2.202178000000e-05 4.151784000000e-09 -4.241584000000e-06 4.181738000000e-09 1.638089000000e-05 4.223091000000e-09 -1.066379000000e-06 4.287381000000e-09 1.499911000000e-05 4.412795000000e-09 -6.938826000000e-07 4.639879000000e-09 1.497335000000e-05 4.989879000000e-09 -1.112244000000e-06 5.339879000000e-09 1.533381000000e-05 5.689879000000e-09 -1.413080000000e-06 6.039879000000e-09 1.562596000000e-05 6.389879000000e-09 -1.714159000000e-06 6.739879000000e-09 1.588070000000e-05 7.000000000000e-09 -2.003826000000e-06)
V_XOR_12 xor_12 0 PWL(0.000000000000e+00 6.995221000000e-06 1.000000000000e-12 6.997984000000e-06 2.000000000000e-12 7.000502000000e-06 5.200000000000e-12 7.006871000000e-06 1.544000000000e-11 7.014253000000e-06 4.820800000000e-11 7.014547000000e-06 1.530656000000e-10 7.014629000000e-06 4.886099000000e-10 7.014537000000e-06 8.386099000000e-10 7.014631000000e-06 9.995000000000e-10 7.014537000000e-06 9.996500000000e-10 7.014541000000e-06 1.000130000000e-09 7.014550000000e-06 1.000271000000e-09 7.014553000000e-06 1.000500000000e-09 7.014556000000e-06 1.000549000000e-09 7.014557000000e-06 1.000579000000e-09 7.014557000000e-06 1.000674000000e-09 7.014559000000e-06 1.000921000000e-09 7.014561000000e-06 1.001177000000e-09 7.014564000000e-06 1.001636000000e-09 7.014567000000e-06 1.002995000000e-09 7.014574000000e-06 1.004717000000e-09 7.014578000000e-06 1.007157000000e-09 7.014583000000e-06 1.009530000000e-09 7.014585000000e-06 1.012064000000e-09 7.014586000000e-06 1.014479000000e-09 7.014587000000e-06 1.016999000000e-09 7.014587000000e-06 1.019780000000e-09 7.014587000000e-06 1.023006000000e-09 7.014586000000e-06 1.025715000000e-09 7.014586000000e-06 1.028767000000e-09 7.014585000000e-06 1.031545000000e-09 7.014585000000e-06 1.034548000000e-09 7.014585000000e-06 1.037295000000e-09 7.014585000000e-06 1.040188000000e-09 7.014584000000e-06 1.042931000000e-09 7.014584000000e-06 1.046095000000e-09 7.014584000000e-06 1.049020000000e-09 7.014584000000e-06 1.051920000000e-09 7.014584000000e-06 1.055268000000e-09 7.014584000000e-06 1.057963000000e-09 7.014584000000e-06 1.059420000000e-09 7.014584000000e-06 1.060877000000e-09 7.014584000000e-06 1.063981000000e-09 7.014584000000e-06 1.066813000000e-09 7.014584000000e-06 1.069715000000e-09 7.014584000000e-06 1.073141000000e-09 7.014584000000e-06 1.075000000000e-09 7.014584000000e-06 1.075500000000e-09 -2.045888000000e-02 1.075834000000e-09 -3.391895000000e-02 1.076000000000e-09 -4.043047000000e-02 1.076266000000e-09 -3.910846000000e-02 1.076419000000e-09 -3.826786000000e-02 1.076822000000e-09 -3.580911000000e-02 1.078112000000e-09 -2.860478000000e-02 1.079915000000e-09 -2.077672000000e-02 1.082834000000e-09 -1.253812000000e-02 1.086452000000e-09 -6.732492000000e-03 1.089863000000e-09 -3.811583000000e-03 1.094093000000e-09 -1.921681000000e-03 1.097558000000e-09 -1.165445000000e-03 1.101264000000e-09 -7.065969000000e-04 1.105520000000e-09 -4.344228000000e-04 1.109056000000e-09 -2.959288000000e-04 1.112992000000e-09 -2.150839000000e-04 1.115807000000e-09 -1.673405000000e-04 1.118621000000e-09 -1.279798000000e-04 1.121942000000e-09 -1.058274000000e-04 1.125724000000e-09 -7.572437000000e-05 1.129501000000e-09 -6.325407000000e-05 1.133249000000e-09 -4.285626000000e-05 1.135809000000e-09 -3.587991000000e-05 1.138369000000e-09 -3.454717000000e-05 1.141791000000e-09 -2.268020000000e-05 1.145734000000e-09 -1.969639000000e-05 1.150017000000e-09 -1.008213000000e-05 1.153865000000e-09 -1.102567000000e-05 1.158361000000e-09 -4.749445000000e-06 1.161824000000e-09 -6.269387000000e-06 1.165535000000e-09 -1.363457000000e-06 1.169527000000e-09 -3.003867000000e-06 1.173109000000e-09 8.420669000000e-07 1.177056000000e-09 -9.416532000000e-07 1.179535000000e-09 1.085021000000e-07 1.182013000000e-09 2.832898000000e-06 1.185429000000e-09 9.436598000000e-07 1.189651000000e-09 3.478254000000e-06 1.193349000000e-09 2.228424000000e-06 1.197208000000e-09 4.178104000000e-06 1.200595000000e-09 2.942033000000e-06 1.204042000000e-09 4.637692000000e-06 1.207661000000e-09 2.967832000000e-06 1.212044000000e-09 4.675520000000e-06 1.215603000000e-09 3.606364000000e-06 1.219624000000e-09 5.349041000000e-06 1.222280000000e-09 7.407919000000e-06 1.224935000000e-09 1.018914000000e-05 1.228316000000e-09 2.604743000000e-05 1.229186000000e-09 2.227162000000e-05 1.230042000000e-09 1.786030000000e-05 1.232779000000e-09 -1.246899000000e-05 1.235670000000e-09 -4.719302000000e-05 1.238863000000e-09 -9.657320000000e-05 1.243639000000e-09 1.535883000000e-04 1.246999000000e-09 7.736715000000e-04 1.250850000000e-09 1.377371000000e-03 1.255187000000e-09 -1.595339000000e-03 1.258822000000e-09 -9.730687000000e-03 1.259631000000e-09 -1.233160000000e-02 1.260438000000e-09 -1.504652000000e-02 1.263021000000e-09 -2.304496000000e-02 1.265957000000e-09 -1.661345000000e-02 1.269137000000e-09 2.913664000000e-02 1.273131000000e-09 1.318760000000e-01 1.276658000000e-09 2.263054000000e-01 1.280195000000e-09 3.046436000000e-01 1.284359000000e-09 3.938805000000e-01 1.288216000000e-09 4.844776000000e-01 1.291735000000e-09 5.653539000000e-01 1.292574000000e-09 5.829428000000e-01 1.293423000000e-09 6.001895000000e-01 1.296139000000e-09 6.487504000000e-01 1.299136000000e-09 6.906812000000e-01 1.302736000000e-09 7.275859000000e-01 1.306959000000e-09 7.576986000000e-01 1.310392000000e-09 7.763778000000e-01 1.314112000000e-09 7.943339000000e-01 1.317424000000e-09 8.084289000000e-01 1.320972000000e-09 8.207928000000e-01 1.324632000000e-09 8.306805000000e-01 1.327145000000e-09 8.359475000000e-01 1.329658000000e-09 8.399749000000e-01 1.333049000000e-09 8.440376000000e-01 1.337028000000e-09 8.475968000000e-01 1.341293000000e-09 8.504901000000e-01 1.345153000000e-09 8.524225000000e-01 1.349994000000e-09 8.540871000000e-01 1.353616000000e-09 8.549541000000e-01 1.357116000000e-09 8.557025000000e-01 1.357983000000e-09 8.558816000000e-01 1.358962000000e-09 8.560810000000e-01 1.362092000000e-09 8.566725000000e-01 1.364885000000e-09 8.571365000000e-01 1.369987000000e-09 8.578508000000e-01 1.373500000000e-09 8.582597000000e-01 1.377230000000e-09 8.586314000000e-01 1.381288000000e-09 8.589647000000e-01 1.384815000000e-09 8.591977000000e-01 1.388662000000e-09 8.593989000000e-01 1.389532000000e-09 8.594363000000e-01 1.390483000000e-09 8.594759000000e-01 1.393528000000e-09 8.595862000000e-01 1.396267000000e-09 8.596662000000e-01 1.399530000000e-09 8.597422000000e-01 1.403009000000e-09 8.598044000000e-01 1.406745000000e-09 8.598544000000e-01 1.410579000000e-09 8.598919000000e-01 1.413057000000e-09 8.599109000000e-01 1.415535000000e-09 8.599257000000e-01 1.418933000000e-09 8.599416000000e-01 1.419781000000e-09 8.599448000000e-01 1.420563000000e-09 8.599476000000e-01 1.423064000000e-09 8.599555000000e-01 1.426220000000e-09 8.599633000000e-01 1.429627000000e-09 8.599696000000e-01 1.432942000000e-09 8.599742000000e-01 1.436511000000e-09 8.599778000000e-01 1.439973000000e-09 8.599804000000e-01 1.444113000000e-09 8.599826000000e-01 1.447667000000e-09 8.599839000000e-01 1.448597000000e-09 8.599841000000e-01 1.449278000000e-09 8.599843000000e-01 1.451458000000e-09 8.599849000000e-01 1.454984000000e-09 8.599855000000e-01 1.458241000000e-09 8.599860000000e-01 1.461761000000e-09 8.599864000000e-01 1.465886000000e-09 8.599867000000e-01 1.469389000000e-09 8.599868000000e-01 1.472794000000e-09 8.599870000000e-01 1.475276000000e-09 8.599873000000e-01 1.477758000000e-09 8.599877000000e-01 1.479095000000e-09 8.599877000000e-01 1.479882000000e-09 8.599876000000e-01 1.482402000000e-09 8.599873000000e-01 1.485321000000e-09 8.599869000000e-01 1.488790000000e-09 8.599867000000e-01 1.492381000000e-09 8.599858000000e-01 1.496661000000e-09 8.599835000000e-01 1.500576000000e-09 8.599830000000e-01 1.504103000000e-09 8.599832000000e-01 1.508121000000e-09 8.599785000000e-01 1.509046000000e-09 8.599774000000e-01 1.509764000000e-09 8.599772000000e-01 1.512062000000e-09 8.599897000000e-01 1.514727000000e-09 8.600324000000e-01 1.518391000000e-09 8.601037000000e-01 1.521668000000e-09 8.601343000000e-01 1.525243000000e-09 8.601279000000e-01 1.529365000000e-09 8.600685000000e-01 1.532875000000e-09 8.598539000000e-01 1.534025000000e-09 8.597186000000e-01 1.534117000000e-09 8.575944000000e-01 1.534180000000e-09 8.562695000000e-01 1.534382000000e-09 8.529561000000e-01 1.534737000000e-09 8.491281000000e-01 1.535025000000e-09 8.480901000000e-01 1.535086000000e-09 8.488310000000e-01 1.535120000000e-09 8.492406000000e-01 1.535227000000e-09 8.503476000000e-01 1.535516000000e-09 8.526097000000e-01 1.535770000000e-09 8.542298000000e-01 1.536253000000e-09 8.565788000000e-01 1.537797000000e-09 8.605223000000e-01 1.540037000000e-09 8.609857000000e-01 1.542991000000e-09 8.596550000000e-01 1.546340000000e-09 8.577377000000e-01 1.549563000000e-09 8.558833000000e-01 1.553023000000e-09 8.573734000000e-01 1.556674000000e-09 8.672803000000e-01 1.561332000000e-09 8.886307000000e-01 1.564959000000e-09 9.047824000000e-01 1.568637000000e-09 9.062549000000e-01 1.572862000000e-09 8.523829000000e-01 1.576410000000e-09 7.441643000000e-01 1.580380000000e-09 5.789241000000e-01 1.584817000000e-09 3.870221000000e-01 1.588226000000e-09 2.663914000000e-01 1.592181000000e-09 1.650904000000e-01 1.595925000000e-09 1.080455000000e-01 1.599741000000e-09 7.405853000000e-02 1.604581000000e-09 4.776644000000e-02 1.606342000000e-09 4.073901000000e-02 1.608103000000e-09 3.506499000000e-02 1.611836000000e-09 2.355681000000e-02 1.616035000000e-09 1.359680000000e-02 1.619218000000e-09 8.526245000000e-03 1.623182000000e-09 4.650774000000e-03 1.626358000000e-09 2.834148000000e-03 1.629985000000e-09 1.612419000000e-03 1.634074000000e-09 8.304383000000e-04 1.638238000000e-09 4.433797000000e-04 1.643068000000e-09 1.988202000000e-04 1.648476000000e-09 9.782739000000e-05 1.653917000000e-09 3.570497000000e-05 1.658595000000e-09 3.291876000000e-05 1.665047000000e-09 7.135423000000e-06 1.668427000000e-09 1.855344000000e-05 1.674362000000e-09 4.308601000000e-07 1.678501000000e-09 1.457066000000e-05 1.684581000000e-09 -9.081146000000e-07 1.686093000000e-09 6.090898000000e-06 1.687486000000e-09 5.365188000000e-06 1.691945000000e-09 6.257948000000e-06 1.695547000000e-09 6.320794000000e-06 1.700342000000e-09 6.189043000000e-06 1.704014000000e-09 6.307748000000e-06 1.707642000000e-09 6.179631000000e-06 1.712914000000e-09 6.302053000000e-06 1.717024000000e-09 6.179985000000e-06 1.722796000000e-09 6.293006000000e-06 1.724262000000e-09 6.233927000000e-06 1.725743000000e-09 6.232524000000e-06 1.730482000000e-09 6.229781000000e-06 1.734128000000e-09 6.226409000000e-06 1.739613000000e-09 6.225703000000e-06 1.743241000000e-09 6.224807000000e-06 1.746998000000e-09 6.224929000000e-06 1.752400000000e-09 6.224032000000e-06 1.756586000000e-09 6.224438000000e-06 1.762468000000e-09 6.223674000000e-06 1.764025000000e-09 6.223977000000e-06 1.765380000000e-09 6.223973000000e-06 1.769719000000e-09 6.223959000000e-06 1.773264000000e-09 6.223941000000e-06 1.778028000000e-09 6.223933000000e-06 1.781718000000e-09 6.223929000000e-06 1.785310000000e-09 6.223926000000e-06 1.790811000000e-09 6.223923000000e-06 1.794844000000e-09 6.223937000000e-06 1.800637000000e-09 6.223914000000e-06 1.802097000000e-09 6.223914000000e-06 1.803580000000e-09 6.223916000000e-06 1.808326000000e-09 6.223923000000e-06 1.811970000000e-09 6.223925000000e-06 1.817496000000e-09 6.223927000000e-06 1.821120000000e-09 6.223927000000e-06 1.824884000000e-09 6.223928000000e-06 1.830308000000e-09 6.223930000000e-06 1.834495000000e-09 6.223934000000e-06 1.840377000000e-09 6.223927000000e-06 1.841939000000e-09 6.223925000000e-06 1.843284000000e-09 6.223925000000e-06 1.847586000000e-09 6.223929000000e-06 1.851115000000e-09 6.223931000000e-06 1.855851000000e-09 6.223932000000e-06 1.859543000000e-09 6.223932000000e-06 1.863125000000e-09 6.223932000000e-06 1.868621000000e-09 6.223933000000e-06 1.872640000000e-09 6.223933000000e-06 1.878406000000e-09 6.223933000000e-06 1.879857000000e-09 6.223933000000e-06 1.881342000000e-09 6.223933000000e-06 1.886097000000e-09 6.223934000000e-06 1.889729000000e-09 6.223933000000e-06 1.895406000000e-09 6.223934000000e-06 1.899019000000e-09 6.223934000000e-06 1.902802000000e-09 6.223934000000e-06 1.908327000000e-09 6.223935000000e-06 1.912510000000e-09 6.223935000000e-06 1.918396000000e-09 6.223935000000e-06 1.923452000000e-09 6.223935000000e-06 1.928319000000e-09 6.223935000000e-06 1.933832000000e-09 6.223936000000e-06 1.937865000000e-09 6.223936000000e-06 1.941516000000e-09 6.223936000000e-06 1.947123000000e-09 6.223936000000e-06 1.951206000000e-09 6.223936000000e-06 1.957151000000e-09 6.223936000000e-06 1.962202000000e-09 6.223936000000e-06 1.967100000000e-09 6.223936000000e-06 1.968013000000e-09 6.223936000000e-06 1.969099000000e-09 6.223936000000e-06 1.972453000000e-09 6.223937000000e-06 1.975701000000e-09 6.223937000000e-06 1.979195000000e-09 6.223937000000e-06 1.983866000000e-09 6.223937000000e-06 1.987814000000e-09 6.223937000000e-06 1.993099000000e-09 6.223937000000e-06 1.998488000000e-09 6.223937000000e-06 2.003935000000e-09 6.223937000000e-06 2.004866000000e-09 6.223937000000e-06 2.005730000000e-09 6.223937000000e-06 2.008495000000e-09 6.223937000000e-06 2.013208000000e-09 6.223937000000e-06 2.016501000000e-09 6.223937000000e-06 2.021215000000e-09 6.223937000000e-06 2.025252000000e-09 6.223937000000e-06 2.030301000000e-09 6.223937000000e-06 2.035760000000e-09 6.223937000000e-06 2.040977000000e-09 6.223938000000e-06 2.042009000000e-09 6.223937000000e-06 2.042812000000e-09 6.223937000000e-06 2.045379000000e-09 6.223938000000e-06 2.049639000000e-09 6.223938000000e-06 2.053254000000e-09 6.223938000000e-06 2.056728000000e-09 6.223938000000e-06 2.062152000000e-09 6.223938000000e-06 2.066039000000e-09 6.223938000000e-06 2.071558000000e-09 6.223938000000e-06 2.076872000000e-09 6.223938000000e-06 2.078300000000e-09 6.223938000000e-06 2.079144000000e-09 6.223938000000e-06 2.081843000000e-09 6.223938000000e-06 2.085459000000e-09 6.223938000000e-06 2.089564000000e-09 6.223938000000e-06 2.093109000000e-09 6.223938000000e-06 2.096789000000e-09 6.223938000000e-06 2.101106000000e-09 6.223938000000e-06 2.105378000000e-09 6.223938000000e-06 2.110838000000e-09 6.223938000000e-06 2.112251000000e-09 6.223938000000e-06 2.113753000000e-09 6.223938000000e-06 2.118558000000e-09 6.223938000000e-06 2.122133000000e-09 6.223938000000e-06 2.129360000000e-09 6.223938000000e-06 2.132821000000e-09 6.223938000000e-06 2.136929000000e-09 6.223938000000e-06 2.139763000000e-09 6.223938000000e-06 2.142597000000e-09 6.223938000000e-06 2.147012000000e-09 6.223938000000e-06 2.152765000000e-09 6.223938000000e-06 2.154377000000e-09 6.223938000000e-06 2.155442000000e-09 6.223938000000e-06 2.158852000000e-09 6.223938000000e-06 2.162621000000e-09 6.223938000000e-06 2.166944000000e-09 6.223938000000e-06 2.170618000000e-09 6.223938000000e-06 2.174167000000e-09 6.223938000000e-06 2.179170000000e-09 6.223938000000e-06 2.183292000000e-09 6.223938000000e-06 2.188867000000e-09 6.223938000000e-06 2.190278000000e-09 6.223938000000e-06 2.191779000000e-09 6.223938000000e-06 2.196584000000e-09 6.223938000000e-06 2.200169000000e-09 6.223938000000e-06 2.207050000000e-09 6.223938000000e-06 2.210543000000e-09 6.223938000000e-06 2.214570000000e-09 6.223938000000e-06 2.217383000000e-09 6.223938000000e-06 2.220196000000e-09 6.223938000000e-06 2.224548000000e-09 6.223938000000e-06 2.230327000000e-09 6.223938000000e-06 2.231668000000e-09 6.223938000000e-06 2.232487000000e-09 6.223938000000e-06 2.235108000000e-09 6.223938000000e-06 2.238430000000e-09 6.223939000000e-06 2.242101000000e-09 6.223939000000e-06 2.245250000000e-09 6.223939000000e-06 2.248623000000e-09 6.223939000000e-06 2.252399000000e-09 6.223939000000e-06 2.256336000000e-09 6.223939000000e-06 2.261919000000e-09 6.223939000000e-06 2.264384000000e-09 6.223939000000e-06 2.265883000000e-09 6.223938000000e-06 2.270679000000e-09 6.223939000000e-06 2.277378000000e-09 6.223939000000e-06 2.283984000000e-09 6.223939000000e-06 2.291963000000e-09 6.223939000000e-06 2.303337000000e-09 6.223939000000e-06 2.323042000000e-09 6.223939000000e-06 2.352076000000e-09 6.223939000000e-06 2.407975000000e-09 6.223939000000e-06 2.543499000000e-09 6.223939000000e-06 2.778736000000e-09 6.223939000000e-06 3.128736000000e-09 6.223939000000e-06 3.478736000000e-09 6.223939000000e-06 3.828736000000e-09 6.223939000000e-06 4.076000000000e-09 6.223939000000e-06 4.076500000000e-09 2.038101000000e-02 4.077000000000e-09 4.007170000000e-02 4.077306000000e-09 3.904965000000e-02 4.077515000000e-09 3.825209000000e-02 4.078112000000e-09 3.571228000000e-02 4.079900000000e-09 2.850068000000e-02 4.082540000000e-09 1.955145000000e-02 4.086501000000e-09 1.040460000000e-02 4.092049000000e-09 3.783465000000e-03 4.100074000000e-09 6.728846000000e-04 4.112222000000e-09 -3.187946000000e-05 4.128358000000e-09 2.202265000000e-05 4.151784000000e-09 -4.243319000000e-06 4.181738000000e-09 1.638230000000e-05 4.223091000000e-09 -1.068458000000e-06 4.287381000000e-09 1.500052000000e-05 4.412795000000e-09 -6.960153000000e-07 4.639879000000e-09 1.497480000000e-05 4.989879000000e-09 -1.114414000000e-06 5.339879000000e-09 1.533525000000e-05 5.689879000000e-09 -1.415250000000e-06 6.039879000000e-09 1.562740000000e-05 6.389879000000e-09 -1.716336000000e-06 6.739879000000e-09 1.588212000000e-05 7.000000000000e-09 -2.006008000000e-06)
V_XOR_13 xor_13 0 PWL(0.000000000000e+00 6.995221000000e-06 1.000000000000e-12 6.997984000000e-06 2.000000000000e-12 7.000502000000e-06 5.200000000000e-12 7.006871000000e-06 1.544000000000e-11 7.014253000000e-06 4.820800000000e-11 7.014547000000e-06 1.530656000000e-10 7.014629000000e-06 4.886099000000e-10 7.014537000000e-06 8.386099000000e-10 7.014631000000e-06 9.995000000000e-10 7.014537000000e-06 9.996500000000e-10 7.014541000000e-06 1.000130000000e-09 7.014550000000e-06 1.000271000000e-09 7.014553000000e-06 1.000500000000e-09 7.014556000000e-06 1.000549000000e-09 7.014557000000e-06 1.000579000000e-09 7.014557000000e-06 1.000674000000e-09 7.014559000000e-06 1.000921000000e-09 7.014561000000e-06 1.001177000000e-09 7.014564000000e-06 1.001636000000e-09 7.014567000000e-06 1.002995000000e-09 7.014574000000e-06 1.004717000000e-09 7.014578000000e-06 1.007157000000e-09 7.014583000000e-06 1.009530000000e-09 7.014585000000e-06 1.012064000000e-09 7.014586000000e-06 1.014479000000e-09 7.014587000000e-06 1.016999000000e-09 7.014587000000e-06 1.019780000000e-09 7.014587000000e-06 1.023006000000e-09 7.014586000000e-06 1.025715000000e-09 7.014586000000e-06 1.028767000000e-09 7.014585000000e-06 1.031545000000e-09 7.014585000000e-06 1.034548000000e-09 7.014585000000e-06 1.037295000000e-09 7.014585000000e-06 1.040188000000e-09 7.014584000000e-06 1.042931000000e-09 7.014584000000e-06 1.046095000000e-09 7.014584000000e-06 1.049020000000e-09 7.014584000000e-06 1.051920000000e-09 7.014584000000e-06 1.055268000000e-09 7.014584000000e-06 1.057963000000e-09 7.014584000000e-06 1.059420000000e-09 7.014584000000e-06 1.060877000000e-09 7.014584000000e-06 1.063981000000e-09 7.014584000000e-06 1.066813000000e-09 7.014584000000e-06 1.069715000000e-09 7.014584000000e-06 1.073141000000e-09 7.014584000000e-06 1.075000000000e-09 7.014584000000e-06 1.075500000000e-09 -2.045888000000e-02 1.075834000000e-09 -3.391895000000e-02 1.076000000000e-09 -4.043047000000e-02 1.076266000000e-09 -3.910846000000e-02 1.076419000000e-09 -3.826786000000e-02 1.076822000000e-09 -3.580911000000e-02 1.078112000000e-09 -2.860478000000e-02 1.079915000000e-09 -2.077672000000e-02 1.082834000000e-09 -1.253812000000e-02 1.086452000000e-09 -6.732492000000e-03 1.089863000000e-09 -3.811583000000e-03 1.094093000000e-09 -1.921681000000e-03 1.097558000000e-09 -1.165445000000e-03 1.101264000000e-09 -7.065969000000e-04 1.105520000000e-09 -4.344228000000e-04 1.109056000000e-09 -2.959288000000e-04 1.112992000000e-09 -2.150839000000e-04 1.115807000000e-09 -1.673405000000e-04 1.118621000000e-09 -1.279798000000e-04 1.121942000000e-09 -1.058274000000e-04 1.125724000000e-09 -7.572437000000e-05 1.129501000000e-09 -6.325407000000e-05 1.133249000000e-09 -4.285626000000e-05 1.135809000000e-09 -3.587991000000e-05 1.138369000000e-09 -3.454717000000e-05 1.141791000000e-09 -2.268020000000e-05 1.145734000000e-09 -1.969639000000e-05 1.150017000000e-09 -1.008213000000e-05 1.153865000000e-09 -1.102566000000e-05 1.158361000000e-09 -4.749447000000e-06 1.161824000000e-09 -6.269399000000e-06 1.165535000000e-09 -1.363382000000e-06 1.169527000000e-09 -3.003997000000e-06 1.173109000000e-09 8.421488000000e-07 1.177056000000e-09 -9.417057000000e-07 1.179535000000e-09 1.080620000000e-07 1.182013000000e-09 2.831837000000e-06 1.185429000000e-09 9.488931000000e-07 1.189651000000e-09 3.475060000000e-06 1.193349000000e-09 2.230036000000e-06 1.197208000000e-09 4.178005000000e-06 1.200595000000e-09 2.904260000000e-06 1.204042000000e-09 4.372903000000e-06 1.207661000000e-09 3.366434000000e-06 1.212044000000e-09 4.821800000000e-06 1.215603000000e-09 3.982350000000e-06 1.219624000000e-09 5.083190000000e-06 1.222280000000e-09 5.149571000000e-06 1.224935000000e-09 4.690532000000e-06 1.228316000000e-09 5.083908000000e-06 1.229186000000e-09 4.981236000000e-06 1.230042000000e-09 4.955228000000e-06 1.232779000000e-09 5.829014000000e-06 1.235670000000e-09 5.836947000000e-06 1.238863000000e-09 5.784725000000e-06 1.243639000000e-09 8.590856000000e-06 1.246999000000e-09 3.016493000000e-05 1.250850000000e-09 -6.231044000000e-06 1.255187000000e-09 -3.556873000000e-05 1.258822000000e-09 -9.804431000000e-05 1.259631000000e-09 -1.063936000000e-04 1.260438000000e-09 -1.149857000000e-04 1.263021000000e-09 -5.517442000000e-05 1.265957000000e-09 3.435455000000e-04 1.269137000000e-09 1.043734000000e-03 1.273131000000e-09 1.240523000000e-03 1.276658000000e-09 -1.866749000000e-03 1.280195000000e-09 -1.019544000000e-02 1.284359000000e-09 -2.209040000000e-02 1.288216000000e-09 -5.179414000000e-03 1.291735000000e-09 6.048210000000e-02 1.292574000000e-09 8.359026000000e-02 1.293423000000e-09 1.073553000000e-01 1.296139000000e-09 1.826245000000e-01 1.299136000000e-09 2.558129000000e-01 1.302736000000e-09 3.319762000000e-01 1.306959000000e-09 4.253497000000e-01 1.310392000000e-09 5.068814000000e-01 1.314112000000e-09 5.894150000000e-01 1.317424000000e-09 6.497214000000e-01 1.320972000000e-09 6.979334000000e-01 1.324632000000e-09 7.331784000000e-01 1.327145000000e-09 7.519388000000e-01 1.329658000000e-09 7.662690000000e-01 1.333049000000e-09 7.835512000000e-01 1.337028000000e-09 8.018157000000e-01 1.341293000000e-09 8.179524000000e-01 1.345153000000e-09 8.290354000000e-01 1.349994000000e-09 8.386791000000e-01 1.353616000000e-09 8.433593000000e-01 1.357116000000e-09 8.466760000000e-01 1.357983000000e-09 8.473681000000e-01 1.358962000000e-09 8.481208000000e-01 1.362092000000e-09 8.502173000000e-01 1.364885000000e-09 8.517207000000e-01 1.369987000000e-09 8.537115000000e-01 1.373500000000e-09 8.546337000000e-01 1.377230000000e-09 8.554555000000e-01 1.381288000000e-09 8.562878000000e-01 1.384815000000e-09 8.569233000000e-01 1.388662000000e-09 8.575105000000e-01 1.389532000000e-09 8.576275000000e-01 1.390483000000e-09 8.577531000000e-01 1.393528000000e-09 8.581241000000e-01 1.396267000000e-09 8.584190000000e-01 1.399530000000e-09 8.587248000000e-01 1.403009000000e-09 8.589982000000e-01 1.406745000000e-09 8.592362000000e-01 1.410579000000e-09 8.594277000000e-01 1.413057000000e-09 8.595284000000e-01 1.415535000000e-09 8.596110000000e-01 1.418933000000e-09 8.597025000000e-01 1.419781000000e-09 8.597211000000e-01 1.420563000000e-09 8.597378000000e-01 1.423064000000e-09 8.597849000000e-01 1.426220000000e-09 8.598324000000e-01 1.429627000000e-09 8.598717000000e-01 1.432942000000e-09 8.599006000000e-01 1.436511000000e-09 8.599238000000e-01 1.439973000000e-09 8.599406000000e-01 1.444113000000e-09 8.599550000000e-01 1.447667000000e-09 8.599638000000e-01 1.448597000000e-09 8.599656000000e-01 1.449278000000e-09 8.599669000000e-01 1.451458000000e-09 8.599705000000e-01 1.454984000000e-09 8.599751000000e-01 1.458241000000e-09 8.599782000000e-01 1.461761000000e-09 8.599807000000e-01 1.465886000000e-09 8.599828000000e-01 1.469389000000e-09 8.599840000000e-01 1.472794000000e-09 8.599849000000e-01 1.475276000000e-09 8.599854000000e-01 1.477758000000e-09 8.599858000000e-01 1.479095000000e-09 8.599860000000e-01 1.479882000000e-09 8.599861000000e-01 1.482402000000e-09 8.599863000000e-01 1.485321000000e-09 8.599865000000e-01 1.488790000000e-09 8.599868000000e-01 1.492381000000e-09 8.599869000000e-01 1.496661000000e-09 8.599870000000e-01 1.500576000000e-09 8.599871000000e-01 1.504103000000e-09 8.599872000000e-01 1.508121000000e-09 8.599872000000e-01 1.509046000000e-09 8.599872000000e-01 1.509764000000e-09 8.599872000000e-01 1.512062000000e-09 8.599874000000e-01 1.514727000000e-09 8.599878000000e-01 1.518391000000e-09 8.599878000000e-01 1.521668000000e-09 8.599873000000e-01 1.525243000000e-09 8.599868000000e-01 1.529365000000e-09 8.599865000000e-01 1.532875000000e-09 8.599851000000e-01 1.534025000000e-09 8.599841000000e-01 1.534117000000e-09 8.578723000000e-01 1.534180000000e-09 8.565559000000e-01 1.534382000000e-09 8.532699000000e-01 1.534737000000e-09 8.494921000000e-01 1.535025000000e-09 8.484949000000e-01 1.535086000000e-09 8.492444000000e-01 1.535120000000e-09 8.496587000000e-01 1.535227000000e-09 8.507807000000e-01 1.535516000000e-09 8.530847000000e-01 1.535770000000e-09 8.547425000000e-01 1.536253000000e-09 8.571651000000e-01 1.537797000000e-09 8.613847000000e-01 1.540037000000e-09 8.622438000000e-01 1.542991000000e-09 8.615738000000e-01 1.546340000000e-09 8.608445000000e-01 1.549563000000e-09 8.604082000000e-01 1.553023000000e-09 8.601565000000e-01 1.556674000000e-09 8.601039000000e-01 1.561332000000e-09 8.600921000000e-01 1.564959000000e-09 8.600946000000e-01 1.568637000000e-09 8.600196000000e-01 1.572862000000e-09 8.597111000000e-01 1.576410000000e-09 8.591706000000e-01 1.580380000000e-09 8.584565000000e-01 1.584817000000e-09 8.570250000000e-01 1.588226000000e-09 8.555165000000e-01 1.592181000000e-09 8.578641000000e-01 1.595925000000e-09 8.689515000000e-01 1.599741000000e-09 8.868213000000e-01 1.604581000000e-09 9.068713000000e-01 1.606342000000e-09 9.068479000000e-01 1.608103000000e-09 9.029210000000e-01 1.611836000000e-09 8.488343000000e-01 1.616035000000e-09 7.139128000000e-01 1.619218000000e-09 5.776251000000e-01 1.623182000000e-09 4.040657000000e-01 1.626358000000e-09 2.876584000000e-01 1.629985000000e-09 1.863185000000e-01 1.634074000000e-09 1.156817000000e-01 1.638238000000e-09 7.608943000000e-02 1.643068000000e-09 4.907067000000e-02 1.648476000000e-09 2.994053000000e-02 1.653917000000e-09 1.544173000000e-02 1.658595000000e-09 7.689586000000e-03 1.665047000000e-09 2.645161000000e-03 1.668427000000e-09 1.564594000000e-03 1.674362000000e-09 5.733165000000e-04 1.678501000000e-09 3.142726000000e-04 1.684581000000e-09 1.099593000000e-04 1.686093000000e-09 9.827690000000e-05 1.687486000000e-09 8.033830000000e-05 1.691945000000e-09 4.452765000000e-05 1.695547000000e-09 3.041274000000e-05 1.700342000000e-09 1.941439000000e-05 1.704014000000e-09 1.458701000000e-05 1.707642000000e-09 1.127784000000e-05 1.712914000000e-09 8.881610000000e-06 1.717024000000e-09 7.838646000000e-06 1.722796000000e-09 7.113397000000e-06 1.724262000000e-09 6.936733000000e-06 1.725743000000e-09 6.833257000000e-06 1.730482000000e-09 6.576311000000e-06 1.734128000000e-09 6.466503000000e-06 1.739613000000e-09 6.355604000000e-06 1.743241000000e-09 6.313492000000e-06 1.746998000000e-09 6.292481000000e-06 1.752400000000e-09 6.277394000000e-06 1.756586000000e-09 6.273380000000e-06 1.762468000000e-09 6.263715000000e-06 1.764025000000e-09 6.263007000000e-06 1.765380000000e-09 6.262358000000e-06 1.769719000000e-09 6.260446000000e-06 1.773264000000e-09 6.259146000000e-06 1.778028000000e-09 6.258032000000e-06 1.781718000000e-09 6.257659000000e-06 1.785310000000e-09 6.257392000000e-06 1.790811000000e-09 6.257059000000e-06 1.794844000000e-09 6.256911000000e-06 1.800637000000e-09 6.256705000000e-06 1.802097000000e-09 6.256713000000e-06 1.803580000000e-09 6.256713000000e-06 1.808326000000e-09 6.256692000000e-06 1.811970000000e-09 6.256674000000e-06 1.817496000000e-09 6.256661000000e-06 1.821120000000e-09 6.256658000000e-06 1.824884000000e-09 6.256665000000e-06 1.830308000000e-09 6.256644000000e-06 1.834495000000e-09 6.256649000000e-06 1.840377000000e-09 6.256649000000e-06 1.841939000000e-09 6.256649000000e-06 1.843284000000e-09 6.256649000000e-06 1.847586000000e-09 6.256650000000e-06 1.851115000000e-09 6.256650000000e-06 1.855851000000e-09 6.256651000000e-06 1.859543000000e-09 6.256651000000e-06 1.863125000000e-09 6.256651000000e-06 1.868621000000e-09 6.256651000000e-06 1.872640000000e-09 6.256651000000e-06 1.878406000000e-09 6.256658000000e-06 1.879857000000e-09 6.256655000000e-06 1.881342000000e-09 6.256651000000e-06 1.886097000000e-09 6.256648000000e-06 1.889729000000e-09 6.256651000000e-06 1.895406000000e-09 6.256653000000e-06 1.899019000000e-09 6.256654000000e-06 1.902802000000e-09 6.256654000000e-06 1.908327000000e-09 6.256654000000e-06 1.912510000000e-09 6.256654000000e-06 1.918396000000e-09 6.256654000000e-06 1.923452000000e-09 6.256654000000e-06 1.928319000000e-09 6.256655000000e-06 1.933832000000e-09 6.256655000000e-06 1.937865000000e-09 6.256655000000e-06 1.941516000000e-09 6.256655000000e-06 1.947123000000e-09 6.256655000000e-06 1.951206000000e-09 6.256655000000e-06 1.957151000000e-09 6.256655000000e-06 1.962202000000e-09 6.256655000000e-06 1.967100000000e-09 6.256656000000e-06 1.968013000000e-09 6.256655000000e-06 1.969099000000e-09 6.256655000000e-06 1.972453000000e-09 6.256672000000e-06 1.975701000000e-09 6.256652000000e-06 1.979195000000e-09 6.256646000000e-06 1.983866000000e-09 6.256652000000e-06 1.987814000000e-09 6.256654000000e-06 1.993099000000e-09 6.256657000000e-06 1.998488000000e-09 6.256657000000e-06 2.003935000000e-09 6.256657000000e-06 2.004866000000e-09 6.256657000000e-06 2.005730000000e-09 6.256657000000e-06 2.008495000000e-09 6.256657000000e-06 2.013208000000e-09 6.256657000000e-06 2.016501000000e-09 6.256657000000e-06 2.021215000000e-09 6.256657000000e-06 2.025252000000e-09 6.256657000000e-06 2.030301000000e-09 6.256657000000e-06 2.035760000000e-09 6.256657000000e-06 2.040977000000e-09 6.256657000000e-06 2.042009000000e-09 6.256657000000e-06 2.042812000000e-09 6.256657000000e-06 2.045379000000e-09 6.256657000000e-06 2.049639000000e-09 6.256657000000e-06 2.053254000000e-09 6.256657000000e-06 2.056728000000e-09 6.256657000000e-06 2.062152000000e-09 6.256657000000e-06 2.066039000000e-09 6.256657000000e-06 2.071558000000e-09 6.256657000000e-06 2.076872000000e-09 6.256657000000e-06 2.078300000000e-09 6.256657000000e-06 2.079144000000e-09 6.256657000000e-06 2.081843000000e-09 6.256657000000e-06 2.085459000000e-09 6.256657000000e-06 2.089564000000e-09 6.256657000000e-06 2.093109000000e-09 6.256657000000e-06 2.096789000000e-09 6.256657000000e-06 2.101106000000e-09 6.256657000000e-06 2.105378000000e-09 6.256657000000e-06 2.110838000000e-09 6.256657000000e-06 2.112251000000e-09 6.256657000000e-06 2.113753000000e-09 6.256657000000e-06 2.118558000000e-09 6.256657000000e-06 2.122133000000e-09 6.256657000000e-06 2.129360000000e-09 6.256657000000e-06 2.132821000000e-09 6.256657000000e-06 2.136929000000e-09 6.256657000000e-06 2.139763000000e-09 6.256657000000e-06 2.142597000000e-09 6.256657000000e-06 2.147012000000e-09 6.256657000000e-06 2.152765000000e-09 6.256657000000e-06 2.154377000000e-09 6.256657000000e-06 2.155442000000e-09 6.256657000000e-06 2.158852000000e-09 6.256657000000e-06 2.162621000000e-09 6.256657000000e-06 2.166944000000e-09 6.256657000000e-06 2.170618000000e-09 6.256657000000e-06 2.174167000000e-09 6.256657000000e-06 2.179170000000e-09 6.256657000000e-06 2.183292000000e-09 6.256657000000e-06 2.188867000000e-09 6.256657000000e-06 2.190278000000e-09 6.256657000000e-06 2.191779000000e-09 6.256657000000e-06 2.196584000000e-09 6.256658000000e-06 2.200169000000e-09 6.256657000000e-06 2.207050000000e-09 6.256658000000e-06 2.210543000000e-09 6.256658000000e-06 2.214570000000e-09 6.256658000000e-06 2.217383000000e-09 6.256658000000e-06 2.220196000000e-09 6.256658000000e-06 2.224548000000e-09 6.256658000000e-06 2.230327000000e-09 6.256658000000e-06 2.231668000000e-09 6.256658000000e-06 2.232487000000e-09 6.256658000000e-06 2.235108000000e-09 6.256658000000e-06 2.238430000000e-09 6.256658000000e-06 2.242101000000e-09 6.256658000000e-06 2.245250000000e-09 6.256658000000e-06 2.248623000000e-09 6.256658000000e-06 2.252399000000e-09 6.256658000000e-06 2.256336000000e-09 6.256658000000e-06 2.261919000000e-09 6.256658000000e-06 2.264384000000e-09 6.256658000000e-06 2.265883000000e-09 6.256658000000e-06 2.270679000000e-09 6.256658000000e-06 2.277378000000e-09 6.256658000000e-06 2.283984000000e-09 6.256657000000e-06 2.291963000000e-09 6.256658000000e-06 2.303337000000e-09 6.256657000000e-06 2.323042000000e-09 6.256658000000e-06 2.352076000000e-09 6.256658000000e-06 2.407975000000e-09 6.256658000000e-06 2.543499000000e-09 6.256658000000e-06 2.778736000000e-09 6.256658000000e-06 3.128736000000e-09 6.256658000000e-06 3.478736000000e-09 6.256658000000e-06 3.828736000000e-09 6.256658000000e-06 4.076000000000e-09 6.256658000000e-06 4.076500000000e-09 2.037644000000e-02 4.077000000000e-09 4.006730000000e-02 4.077306000000e-09 3.904548000000e-02 4.077515000000e-09 3.824806000000e-02 4.078112000000e-09 3.570866000000e-02 4.079900000000e-09 2.849811000000e-02 4.082540000000e-09 1.954987000000e-02 4.086501000000e-09 1.040377000000e-02 4.092049000000e-09 3.783157000000e-03 4.100074000000e-09 6.728320000000e-04 4.112222000000e-09 -3.187713000000e-05 4.128358000000e-09 2.202232000000e-05 4.151784000000e-09 -4.243433000000e-06 4.181738000000e-09 1.638227000000e-05 4.223091000000e-09 -1.068827000000e-06 4.287381000000e-09 1.500051000000e-05 4.412795000000e-09 -6.964353000000e-07 4.639879000000e-09 1.497481000000e-05 4.989879000000e-09 -1.114843000000e-06 5.339879000000e-09 1.533525000000e-05 5.689879000000e-09 -1.415671000000e-06 6.039879000000e-09 1.562738000000e-05 6.389879000000e-09 -1.716754000000e-06 6.739879000000e-09 1.588210000000e-05 7.000000000000e-09 -2.006425000000e-06)
V_XOR_14 xor_14 0 PWL(0.000000000000e+00 6.995221000000e-06 1.000000000000e-12 6.997984000000e-06 2.000000000000e-12 7.000502000000e-06 5.200000000000e-12 7.006871000000e-06 1.544000000000e-11 7.014253000000e-06 4.820800000000e-11 7.014547000000e-06 1.530656000000e-10 7.014629000000e-06 4.886099000000e-10 7.014537000000e-06 8.386099000000e-10 7.014631000000e-06 9.995000000000e-10 7.014537000000e-06 9.996500000000e-10 7.014541000000e-06 1.000130000000e-09 7.014550000000e-06 1.000271000000e-09 7.014553000000e-06 1.000500000000e-09 7.014556000000e-06 1.000549000000e-09 7.014557000000e-06 1.000579000000e-09 7.014557000000e-06 1.000674000000e-09 7.014559000000e-06 1.000921000000e-09 7.014561000000e-06 1.001177000000e-09 7.014564000000e-06 1.001636000000e-09 7.014567000000e-06 1.002995000000e-09 7.014574000000e-06 1.004717000000e-09 7.014578000000e-06 1.007157000000e-09 7.014583000000e-06 1.009530000000e-09 7.014585000000e-06 1.012064000000e-09 7.014586000000e-06 1.014479000000e-09 7.014587000000e-06 1.016999000000e-09 7.014587000000e-06 1.019780000000e-09 7.014587000000e-06 1.023006000000e-09 7.014586000000e-06 1.025715000000e-09 7.014586000000e-06 1.028767000000e-09 7.014585000000e-06 1.031545000000e-09 7.014585000000e-06 1.034548000000e-09 7.014585000000e-06 1.037295000000e-09 7.014585000000e-06 1.040188000000e-09 7.014584000000e-06 1.042931000000e-09 7.014584000000e-06 1.046095000000e-09 7.014584000000e-06 1.049020000000e-09 7.014584000000e-06 1.051920000000e-09 7.014584000000e-06 1.055268000000e-09 7.014584000000e-06 1.057963000000e-09 7.014584000000e-06 1.059420000000e-09 7.014584000000e-06 1.060877000000e-09 7.014584000000e-06 1.063981000000e-09 7.014584000000e-06 1.066813000000e-09 7.014584000000e-06 1.069715000000e-09 7.014584000000e-06 1.073141000000e-09 7.014584000000e-06 1.075000000000e-09 7.014584000000e-06 1.075500000000e-09 -2.045888000000e-02 1.075834000000e-09 -3.391895000000e-02 1.076000000000e-09 -4.043047000000e-02 1.076266000000e-09 -3.910846000000e-02 1.076419000000e-09 -3.826786000000e-02 1.076822000000e-09 -3.580911000000e-02 1.078112000000e-09 -2.860478000000e-02 1.079915000000e-09 -2.077672000000e-02 1.082834000000e-09 -1.253812000000e-02 1.086452000000e-09 -6.732492000000e-03 1.089863000000e-09 -3.811583000000e-03 1.094093000000e-09 -1.921681000000e-03 1.097558000000e-09 -1.165445000000e-03 1.101264000000e-09 -7.065969000000e-04 1.105520000000e-09 -4.344228000000e-04 1.109056000000e-09 -2.959288000000e-04 1.112992000000e-09 -2.150839000000e-04 1.115807000000e-09 -1.673405000000e-04 1.118621000000e-09 -1.279798000000e-04 1.121942000000e-09 -1.058274000000e-04 1.125724000000e-09 -7.572437000000e-05 1.129501000000e-09 -6.325407000000e-05 1.133249000000e-09 -4.285626000000e-05 1.135809000000e-09 -3.587991000000e-05 1.138369000000e-09 -3.454717000000e-05 1.141791000000e-09 -2.268020000000e-05 1.145734000000e-09 -1.969639000000e-05 1.150017000000e-09 -1.008213000000e-05 1.153865000000e-09 -1.102566000000e-05 1.158361000000e-09 -4.749447000000e-06 1.161824000000e-09 -6.269400000000e-06 1.165535000000e-09 -1.363381000000e-06 1.169527000000e-09 -3.003999000000e-06 1.173109000000e-09 8.421521000000e-07 1.177056000000e-09 -9.417077000000e-07 1.179535000000e-09 1.080577000000e-07 1.182013000000e-09 2.831831000000e-06 1.185429000000e-09 9.489734000000e-07 1.189651000000e-09 3.474937000000e-06 1.193349000000e-09 2.230146000000e-06 1.197208000000e-09 4.177975000000e-06 1.200595000000e-09 2.903841000000e-06 1.204042000000e-09 4.370461000000e-06 1.207661000000e-09 3.378197000000e-06 1.212044000000e-09 4.811910000000e-06 1.215603000000e-09 3.986786000000e-06 1.219624000000e-09 5.079896000000e-06 1.222280000000e-09 5.069564000000e-06 1.224935000000e-09 4.476849000000e-06 1.228316000000e-09 5.345742000000e-06 1.229186000000e-09 5.229159000000e-06 1.230042000000e-09 5.198584000000e-06 1.232779000000e-09 6.115698000000e-06 1.235670000000e-09 6.060168000000e-06 1.238863000000e-09 6.022468000000e-06 1.243639000000e-09 5.962307000000e-06 1.246999000000e-09 6.326473000000e-06 1.250850000000e-09 5.468323000000e-06 1.255187000000e-09 5.712104000000e-06 1.258822000000e-09 5.557281000000e-06 1.259631000000e-09 5.728253000000e-06 1.260438000000e-09 5.833868000000e-06 1.263021000000e-09 7.133119000000e-06 1.265957000000e-09 1.114189000000e-05 1.269137000000e-09 2.865894000000e-05 1.273131000000e-09 9.613726000000e-06 1.276658000000e-09 -2.457324000000e-05 1.280195000000e-09 -8.504915000000e-05 1.284359000000e-09 -2.567444000000e-05 1.288216000000e-09 5.107885000000e-04 1.291735000000e-09 1.258001000000e-03 1.292574000000e-09 1.359729000000e-03 1.293423000000e-09 1.425263000000e-03 1.296139000000e-09 3.804484000000e-04 1.299136000000e-09 -4.134807000000e-03 1.302736000000e-09 -1.440506000000e-02 1.306959000000e-09 -1.997400000000e-02 1.310392000000e-09 7.687222000000e-03 1.314112000000e-09 8.942303000000e-02 1.317424000000e-09 1.816594000000e-01 1.320972000000e-09 2.676071000000e-01 1.324632000000e-09 3.446373000000e-01 1.327145000000e-09 4.003904000000e-01 1.329658000000e-09 4.584718000000e-01 1.333049000000e-09 5.386657000000e-01 1.337028000000e-09 6.209781000000e-01 1.341293000000e-09 6.864610000000e-01 1.345153000000e-09 7.268735000000e-01 1.349994000000e-09 7.609248000000e-01 1.353616000000e-09 7.800650000000e-01 1.357116000000e-09 7.966093000000e-01 1.357983000000e-09 8.003592000000e-01 1.358962000000e-09 8.044736000000e-01 1.362092000000e-09 8.161862000000e-01 1.364885000000e-09 8.248302000000e-01 1.369987000000e-09 8.364701000000e-01 1.373500000000e-09 8.416881000000e-01 1.377230000000e-09 8.456204000000e-01 1.381288000000e-09 8.488627000000e-01 1.384815000000e-09 8.510342000000e-01 1.388662000000e-09 8.528104000000e-01 1.389532000000e-09 8.531212000000e-01 1.390483000000e-09 8.534450000000e-01 1.393528000000e-09 8.543151000000e-01 1.396267000000e-09 8.549573000000e-01 1.399530000000e-09 8.556664000000e-01 1.403009000000e-09 8.563686000000e-01 1.406745000000e-09 8.570250000000e-01 1.410579000000e-09 8.575938000000e-01 1.413057000000e-09 8.579168000000e-01 1.415535000000e-09 8.582046000000e-01 1.418933000000e-09 8.585544000000e-01 1.419781000000e-09 8.586318000000e-01 1.420563000000e-09 8.587016000000e-01 1.423064000000e-09 8.589067000000e-01 1.426220000000e-09 8.591274000000e-01 1.429627000000e-09 8.593218000000e-01 1.432942000000e-09 8.594731000000e-01 1.436511000000e-09 8.596008000000e-01 1.439973000000e-09 8.596961000000e-01 1.444113000000e-09 8.597814000000e-01 1.447667000000e-09 8.598350000000e-01 1.448597000000e-09 8.598462000000e-01 1.449278000000e-09 8.598542000000e-01 1.451458000000e-09 8.598769000000e-01 1.454984000000e-09 8.599060000000e-01 1.458241000000e-09 8.599262000000e-01 1.461761000000e-09 8.599425000000e-01 1.465886000000e-09 8.599563000000e-01 1.469389000000e-09 8.599647000000e-01 1.472794000000e-09 8.599706000000e-01 1.475276000000e-09 8.599740000000e-01 1.477758000000e-09 8.599767000000e-01 1.479095000000e-09 8.599778000000e-01 1.479882000000e-09 8.599785000000e-01 1.482402000000e-09 8.599803000000e-01 1.485321000000e-09 8.599819000000e-01 1.488790000000e-09 8.599834000000e-01 1.492381000000e-09 8.599845000000e-01 1.496661000000e-09 8.599854000000e-01 1.500576000000e-09 8.599860000000e-01 1.504103000000e-09 8.599864000000e-01 1.508121000000e-09 8.599867000000e-01 1.509046000000e-09 8.599867000000e-01 1.509764000000e-09 8.599868000000e-01 1.512062000000e-09 8.599869000000e-01 1.514727000000e-09 8.599870000000e-01 1.518391000000e-09 8.599871000000e-01 1.521668000000e-09 8.599871000000e-01 1.525243000000e-09 8.599872000000e-01 1.529365000000e-09 8.599872000000e-01 1.532875000000e-09 8.599872000000e-01 1.534025000000e-09 8.599872000000e-01 1.534117000000e-09 8.578755000000e-01 1.534180000000e-09 8.565592000000e-01 1.534382000000e-09 8.532733000000e-01 1.534737000000e-09 8.494957000000e-01 1.535025000000e-09 8.484987000000e-01 1.535086000000e-09 8.492482000000e-01 1.535120000000e-09 8.496625000000e-01 1.535227000000e-09 8.507846000000e-01 1.535516000000e-09 8.530887000000e-01 1.535770000000e-09 8.547466000000e-01 1.536253000000e-09 8.571688000000e-01 1.537797000000e-09 8.613886000000e-01 1.540037000000e-09 8.622476000000e-01 1.542991000000e-09 8.615781000000e-01 1.546340000000e-09 8.608532000000e-01 1.549563000000e-09 8.604166000000e-01 1.553023000000e-09 8.601242000000e-01 1.556674000000e-09 8.600014000000e-01 1.561332000000e-09 8.599396000000e-01 1.564959000000e-09 8.599559000000e-01 1.568637000000e-09 8.599502000000e-01 1.572862000000e-09 8.599696000000e-01 1.576410000000e-09 8.599605000000e-01 1.580380000000e-09 8.599795000000e-01 1.584817000000e-09 8.599664000000e-01 1.588226000000e-09 8.599795000000e-01 1.592181000000e-09 8.600122000000e-01 1.595925000000e-09 8.601065000000e-01 1.599741000000e-09 8.601270000000e-01 1.604581000000e-09 8.601255000000e-01 1.606342000000e-09 8.600829000000e-01 1.608103000000e-09 8.600179000000e-01 1.611836000000e-09 8.597083000000e-01 1.616035000000e-09 8.590481000000e-01 1.619218000000e-09 8.584639000000e-01 1.623182000000e-09 8.572364000000e-01 1.626358000000e-09 8.557477000000e-01 1.629985000000e-09 8.564454000000e-01 1.634074000000e-09 8.662824000000e-01 1.638238000000e-09 8.851003000000e-01 1.643068000000e-09 9.060253000000e-01 1.648476000000e-09 8.842021000000e-01 1.653917000000e-09 7.494403000000e-01 1.658595000000e-09 5.534050000000e-01 1.665047000000e-09 2.964564000000e-01 1.668427000000e-09 1.973854000000e-01 1.674362000000e-09 9.927748000000e-02 1.678501000000e-09 6.692069000000e-02 1.684581000000e-09 3.853290000000e-02 1.686093000000e-09 3.376146000000e-02 1.687486000000e-09 2.947405000000e-02 1.691945000000e-09 1.748567000000e-02 1.695547000000e-09 1.051892000000e-02 1.700342000000e-09 5.035038000000e-03 1.704014000000e-09 2.838084000000e-03 1.707642000000e-09 1.603437000000e-03 1.712914000000e-09 6.786502000000e-04 1.717024000000e-09 3.580515000000e-04 1.722796000000e-09 1.445816000000e-04 1.724262000000e-09 1.196635000000e-04 1.725743000000e-09 9.712005000000e-05 1.730482000000e-09 5.120211000000e-05 1.734128000000e-09 3.353155000000e-05 1.739613000000e-09 1.975026000000e-05 1.743241000000e-09 1.464642000000e-05 1.746998000000e-09 1.126175000000e-05 1.752400000000e-09 8.691251000000e-06 1.756586000000e-09 7.772775000000e-06 1.762468000000e-09 6.954982000000e-06 1.764025000000e-09 6.842671000000e-06 1.765380000000e-09 6.751972000000e-06 1.769719000000e-09 6.545170000000e-06 1.773264000000e-09 6.437281000000e-06 1.778028000000e-09 6.333992000000e-06 1.781718000000e-09 6.289736000000e-06 1.785310000000e-09 6.265779000000e-06 1.790811000000e-09 6.248332000000e-06 1.794844000000e-09 6.244248000000e-06 1.800637000000e-09 6.234255000000e-06 1.802097000000e-09 6.233364000000e-06 1.803580000000e-09 6.232477000000e-06 1.808326000000e-09 6.230213000000e-06 1.811970000000e-09 6.228860000000e-06 1.817496000000e-09 6.227610000000e-06 1.821120000000e-09 6.227233000000e-06 1.824884000000e-09 6.226999000000e-06 1.830308000000e-09 6.226672000000e-06 1.834495000000e-09 6.226506000000e-06 1.840377000000e-09 6.226350000000e-06 1.841939000000e-09 6.226347000000e-06 1.843284000000e-09 6.226342000000e-06 1.847586000000e-09 6.226323000000e-06 1.851115000000e-09 6.226308000000e-06 1.855851000000e-09 6.226297000000e-06 1.859543000000e-09 6.226294000000e-06 1.863125000000e-09 6.226289000000e-06 1.868621000000e-09 6.226285000000e-06 1.872640000000e-09 6.226284000000e-06 1.878406000000e-09 6.226283000000e-06 1.879857000000e-09 6.226283000000e-06 1.881342000000e-09 6.226283000000e-06 1.886097000000e-09 6.226283000000e-06 1.889729000000e-09 6.226266000000e-06 1.895406000000e-09 6.226308000000e-06 1.899019000000e-09 6.226280000000e-06 1.902802000000e-09 6.226278000000e-06 1.908327000000e-09 6.226282000000e-06 1.912510000000e-09 6.226283000000e-06 1.918396000000e-09 6.226284000000e-06 1.923452000000e-09 6.226284000000e-06 1.928319000000e-09 6.226284000000e-06 1.933832000000e-09 6.226284000000e-06 1.937865000000e-09 6.226285000000e-06 1.941516000000e-09 6.226284000000e-06 1.947123000000e-09 6.226285000000e-06 1.951206000000e-09 6.226284000000e-06 1.957151000000e-09 6.226285000000e-06 1.962202000000e-09 6.226285000000e-06 1.967100000000e-09 6.226285000000e-06 1.968013000000e-09 6.226285000000e-06 1.969099000000e-09 6.226285000000e-06 1.972453000000e-09 6.226285000000e-06 1.975701000000e-09 6.226285000000e-06 1.979195000000e-09 6.226285000000e-06 1.983866000000e-09 6.226285000000e-06 1.987814000000e-09 6.226286000000e-06 1.993099000000e-09 6.226286000000e-06 1.998488000000e-09 6.226285000000e-06 2.003935000000e-09 6.226286000000e-06 2.004866000000e-09 6.226286000000e-06 2.005730000000e-09 6.226286000000e-06 2.008495000000e-09 6.226286000000e-06 2.013208000000e-09 6.226286000000e-06 2.016501000000e-09 6.226286000000e-06 2.021215000000e-09 6.226286000000e-06 2.025252000000e-09 6.226286000000e-06 2.030301000000e-09 6.226286000000e-06 2.035760000000e-09 6.226286000000e-06 2.040977000000e-09 6.226286000000e-06 2.042009000000e-09 6.226286000000e-06 2.042812000000e-09 6.226286000000e-06 2.045379000000e-09 6.226286000000e-06 2.049639000000e-09 6.226286000000e-06 2.053254000000e-09 6.226286000000e-06 2.056728000000e-09 6.226286000000e-06 2.062152000000e-09 6.226286000000e-06 2.066039000000e-09 6.226286000000e-06 2.071558000000e-09 6.226286000000e-06 2.076872000000e-09 6.226286000000e-06 2.078300000000e-09 6.226286000000e-06 2.079144000000e-09 6.226286000000e-06 2.081843000000e-09 6.226287000000e-06 2.085459000000e-09 6.226287000000e-06 2.089564000000e-09 6.226287000000e-06 2.093109000000e-09 6.226287000000e-06 2.096789000000e-09 6.226287000000e-06 2.101106000000e-09 6.226287000000e-06 2.105378000000e-09 6.226287000000e-06 2.110838000000e-09 6.226287000000e-06 2.112251000000e-09 6.226287000000e-06 2.113753000000e-09 6.226287000000e-06 2.118558000000e-09 6.226287000000e-06 2.122133000000e-09 6.226287000000e-06 2.129360000000e-09 6.226287000000e-06 2.132821000000e-09 6.226287000000e-06 2.136929000000e-09 6.226287000000e-06 2.139763000000e-09 6.226287000000e-06 2.142597000000e-09 6.226287000000e-06 2.147012000000e-09 6.226287000000e-06 2.152765000000e-09 6.226287000000e-06 2.154377000000e-09 6.226287000000e-06 2.155442000000e-09 6.226287000000e-06 2.158852000000e-09 6.226287000000e-06 2.162621000000e-09 6.226287000000e-06 2.166944000000e-09 6.226287000000e-06 2.170618000000e-09 6.226287000000e-06 2.174167000000e-09 6.226287000000e-06 2.179170000000e-09 6.226287000000e-06 2.183292000000e-09 6.226287000000e-06 2.188867000000e-09 6.226287000000e-06 2.190278000000e-09 6.226287000000e-06 2.191779000000e-09 6.226287000000e-06 2.196584000000e-09 6.226287000000e-06 2.200169000000e-09 6.226287000000e-06 2.207050000000e-09 6.226287000000e-06 2.210543000000e-09 6.226287000000e-06 2.214570000000e-09 6.226287000000e-06 2.217383000000e-09 6.226287000000e-06 2.220196000000e-09 6.226287000000e-06 2.224548000000e-09 6.226287000000e-06 2.230327000000e-09 6.226287000000e-06 2.231668000000e-09 6.226287000000e-06 2.232487000000e-09 6.226287000000e-06 2.235108000000e-09 6.226287000000e-06 2.238430000000e-09 6.226287000000e-06 2.242101000000e-09 6.226287000000e-06 2.245250000000e-09 6.226287000000e-06 2.248623000000e-09 6.226287000000e-06 2.252399000000e-09 6.226287000000e-06 2.256336000000e-09 6.226287000000e-06 2.261919000000e-09 6.226287000000e-06 2.264384000000e-09 6.226287000000e-06 2.265883000000e-09 6.226287000000e-06 2.270679000000e-09 6.226287000000e-06 2.277378000000e-09 6.226287000000e-06 2.283984000000e-09 6.226287000000e-06 2.291963000000e-09 6.226287000000e-06 2.303337000000e-09 6.226287000000e-06 2.323042000000e-09 6.226287000000e-06 2.352076000000e-09 6.226287000000e-06 2.407975000000e-09 6.226287000000e-06 2.543499000000e-09 6.226288000000e-06 2.778736000000e-09 6.226288000000e-06 3.128736000000e-09 6.226288000000e-06 3.478736000000e-09 6.226288000000e-06 3.828736000000e-09 6.226288000000e-06 4.076000000000e-09 6.226288000000e-06 4.076500000000e-09 2.037630000000e-02 4.077000000000e-09 4.006729000000e-02 4.077306000000e-09 3.904553000000e-02 4.077515000000e-09 3.824815000000e-02 4.078112000000e-09 3.570879000000e-02 4.079900000000e-09 2.849820000000e-02 4.082540000000e-09 1.954985000000e-02 4.086501000000e-09 1.040372000000e-02 4.092049000000e-09 3.783131000000e-03 4.100074000000e-09 6.728262000000e-04 4.112222000000e-09 -3.187677000000e-05 4.128358000000e-09 2.202217000000e-05 4.151784000000e-09 -4.243291000000e-06 4.181738000000e-09 1.638219000000e-05 4.223091000000e-09 -1.068698000000e-06 4.287381000000e-09 1.500046000000e-05 4.412795000000e-09 -6.963085000000e-07 4.639879000000e-09 1.497477000000e-05 4.989879000000e-09 -1.114718000000e-06 5.339879000000e-09 1.533521000000e-05 5.689879000000e-09 -1.415551000000e-06 6.039879000000e-09 1.562735000000e-05 6.389879000000e-09 -1.716639000000e-06 6.739879000000e-09 1.588207000000e-05 7.000000000000e-09 -2.006314000000e-06)
V_XOR_15 xor_15 0 PWL(0.000000000000e+00 6.995221000000e-06 1.000000000000e-12 6.997984000000e-06 2.000000000000e-12 7.000502000000e-06 5.200000000000e-12 7.006871000000e-06 1.544000000000e-11 7.014253000000e-06 4.820800000000e-11 7.014547000000e-06 1.530656000000e-10 7.014629000000e-06 4.886099000000e-10 7.014537000000e-06 8.386099000000e-10 7.014631000000e-06 9.995000000000e-10 7.014537000000e-06 9.996500000000e-10 7.014541000000e-06 1.000130000000e-09 7.014550000000e-06 1.000271000000e-09 7.014553000000e-06 1.000500000000e-09 7.014556000000e-06 1.000549000000e-09 7.014557000000e-06 1.000579000000e-09 7.014557000000e-06 1.000674000000e-09 7.014559000000e-06 1.000921000000e-09 7.014561000000e-06 1.001177000000e-09 7.014564000000e-06 1.001636000000e-09 7.014567000000e-06 1.002995000000e-09 7.014574000000e-06 1.004717000000e-09 7.014578000000e-06 1.007157000000e-09 7.014583000000e-06 1.009530000000e-09 7.014585000000e-06 1.012064000000e-09 7.014586000000e-06 1.014479000000e-09 7.014587000000e-06 1.016999000000e-09 7.014587000000e-06 1.019780000000e-09 7.014587000000e-06 1.023006000000e-09 7.014586000000e-06 1.025715000000e-09 7.014586000000e-06 1.028767000000e-09 7.014585000000e-06 1.031545000000e-09 7.014585000000e-06 1.034548000000e-09 7.014585000000e-06 1.037295000000e-09 7.014585000000e-06 1.040188000000e-09 7.014584000000e-06 1.042931000000e-09 7.014584000000e-06 1.046095000000e-09 7.014584000000e-06 1.049020000000e-09 7.014584000000e-06 1.051920000000e-09 7.014584000000e-06 1.055268000000e-09 7.014584000000e-06 1.057963000000e-09 7.014584000000e-06 1.059420000000e-09 7.014584000000e-06 1.060877000000e-09 7.014584000000e-06 1.063981000000e-09 7.014584000000e-06 1.066813000000e-09 7.014584000000e-06 1.069715000000e-09 7.014584000000e-06 1.073141000000e-09 7.014584000000e-06 1.075000000000e-09 7.014584000000e-06 1.075500000000e-09 -2.045888000000e-02 1.075834000000e-09 -3.391895000000e-02 1.076000000000e-09 -4.043047000000e-02 1.076266000000e-09 -3.910846000000e-02 1.076419000000e-09 -3.826786000000e-02 1.076822000000e-09 -3.580911000000e-02 1.078112000000e-09 -2.860478000000e-02 1.079915000000e-09 -2.077672000000e-02 1.082834000000e-09 -1.253812000000e-02 1.086452000000e-09 -6.732492000000e-03 1.089863000000e-09 -3.811583000000e-03 1.094093000000e-09 -1.921681000000e-03 1.097558000000e-09 -1.165445000000e-03 1.101264000000e-09 -7.065969000000e-04 1.105520000000e-09 -4.344228000000e-04 1.109056000000e-09 -2.959288000000e-04 1.112992000000e-09 -2.150839000000e-04 1.115807000000e-09 -1.673405000000e-04 1.118621000000e-09 -1.279798000000e-04 1.121942000000e-09 -1.058274000000e-04 1.125724000000e-09 -7.572437000000e-05 1.129501000000e-09 -6.325407000000e-05 1.133249000000e-09 -4.285626000000e-05 1.135809000000e-09 -3.587991000000e-05 1.138369000000e-09 -3.454717000000e-05 1.141791000000e-09 -2.268020000000e-05 1.145734000000e-09 -1.969639000000e-05 1.150017000000e-09 -1.008213000000e-05 1.153865000000e-09 -1.102566000000e-05 1.158361000000e-09 -4.749447000000e-06 1.161824000000e-09 -6.269400000000e-06 1.165535000000e-09 -1.363381000000e-06 1.169527000000e-09 -3.004000000000e-06 1.173109000000e-09 8.421522000000e-07 1.177056000000e-09 -9.417078000000e-07 1.179535000000e-09 1.080576000000e-07 1.182013000000e-09 2.831831000000e-06 1.185429000000e-09 9.489744000000e-07 1.189651000000e-09 3.474935000000e-06 1.193349000000e-09 2.230150000000e-06 1.197208000000e-09 4.177973000000e-06 1.200595000000e-09 2.903837000000e-06 1.204042000000e-09 4.370442000000e-06 1.207661000000e-09 3.378368000000e-06 1.212044000000e-09 4.811627000000e-06 1.215603000000e-09 3.987091000000e-06 1.219624000000e-09 5.079818000000e-06 1.222280000000e-09 5.068917000000e-06 1.224935000000e-09 4.475383000000e-06 1.228316000000e-09 5.352156000000e-06 1.229186000000e-09 5.237821000000e-06 1.230042000000e-09 5.195514000000e-06 1.232779000000e-09 6.109945000000e-06 1.235670000000e-09 6.043144000000e-06 1.238863000000e-09 6.018221000000e-06 1.243639000000e-09 5.932162000000e-06 1.246999000000e-09 5.997082000000e-06 1.250850000000e-09 5.909277000000e-06 1.255187000000e-09 6.004092000000e-06 1.258822000000e-09 5.923903000000e-06 1.259631000000e-09 5.958080000000e-06 1.260438000000e-09 5.964774000000e-06 1.263021000000e-09 5.979524000000e-06 1.265957000000e-09 6.362334000000e-06 1.269137000000e-09 5.590114000000e-06 1.273131000000e-09 5.717719000000e-06 1.276658000000e-09 5.766080000000e-06 1.280195000000e-09 5.569299000000e-06 1.284359000000e-09 6.977980000000e-06 1.288216000000e-09 1.141136000000e-05 1.291735000000e-09 2.737664000000e-05 1.292574000000e-09 2.389126000000e-05 1.293423000000e-09 1.985290000000e-05 1.296139000000e-09 -5.923307000000e-06 1.299136000000e-09 -4.059459000000e-05 1.302736000000e-09 -9.970101000000e-05 1.306959000000e-09 1.017394000000e-04 1.310392000000e-09 7.210948000000e-04 1.314112000000e-09 1.384086000000e-03 1.317424000000e-09 2.863429000000e-04 1.320972000000e-09 -5.421759000000e-03 1.324632000000e-09 -1.668263000000e-02 1.327145000000e-09 -1.641190000000e-02 1.329658000000e-09 -9.624812000000e-03 1.333049000000e-09 3.762523000000e-02 1.337028000000e-09 1.385960000000e-01 1.341293000000e-09 2.483770000000e-01 1.345153000000e-09 3.312771000000e-01 1.349994000000e-09 4.388372000000e-01 1.353616000000e-09 5.248107000000e-01 1.357116000000e-09 6.005023000000e-01 1.357983000000e-09 6.167274000000e-01 1.358962000000e-09 6.342701000000e-01 1.362092000000e-09 6.814553000000e-01 1.364885000000e-09 7.132955000000e-01 1.369987000000e-09 7.537822000000e-01 1.373500000000e-09 7.734775000000e-01 1.377230000000e-09 7.917568000000e-01 1.381288000000e-09 8.091401000000e-01 1.384815000000e-09 8.213216000000e-01 1.388662000000e-09 8.314989000000e-01 1.389532000000e-09 8.332988000000e-01 1.390483000000e-09 8.351738000000e-01 1.393528000000e-09 8.401066000000e-01 1.396267000000e-09 8.434361000000e-01 1.399530000000e-09 8.465580000000e-01 1.403009000000e-09 8.492005000000e-01 1.406745000000e-09 8.514030000000e-01 1.410579000000e-09 8.530706000000e-01 1.413057000000e-09 8.539000000000e-01 1.415535000000e-09 8.545342000000e-01 1.418933000000e-09 8.552891000000e-01 1.419781000000e-09 8.554706000000e-01 1.420563000000e-09 8.556379000000e-01 1.423064000000e-09 8.561537000000e-01 1.426220000000e-09 8.567429000000e-01 1.429627000000e-09 8.572925000000e-01 1.432942000000e-09 8.577532000000e-01 1.436511000000e-09 8.581834000000e-01 1.439973000000e-09 8.585421000000e-01 1.444113000000e-09 8.588989000000e-01 1.447667000000e-09 8.591461000000e-01 1.448597000000e-09 8.592006000000e-01 1.449278000000e-09 8.592398000000e-01 1.451458000000e-09 8.593540000000e-01 1.454984000000e-09 8.595067000000e-01 1.458241000000e-09 8.596172000000e-01 1.461761000000e-09 8.597101000000e-01 1.465886000000e-09 8.597911000000e-01 1.469389000000e-09 8.598417000000e-01 1.472794000000e-09 8.598787000000e-01 1.475276000000e-09 8.599001000000e-01 1.477758000000e-09 8.599170000000e-01 1.479095000000e-09 8.599244000000e-01 1.479882000000e-09 8.599286000000e-01 1.482402000000e-09 8.599402000000e-01 1.485321000000e-09 8.599510000000e-01 1.488790000000e-09 8.599606000000e-01 1.492381000000e-09 8.599680000000e-01 1.496661000000e-09 8.599742000000e-01 1.500576000000e-09 8.599781000000e-01 1.504103000000e-09 8.599806000000e-01 1.508121000000e-09 8.599827000000e-01 1.509046000000e-09 8.599830000000e-01 1.509764000000e-09 8.599833000000e-01 1.512062000000e-09 8.599841000000e-01 1.514727000000e-09 8.599848000000e-01 1.518391000000e-09 8.599855000000e-01 1.521668000000e-09 8.599860000000e-01 1.525243000000e-09 8.599863000000e-01 1.529365000000e-09 8.599867000000e-01 1.532875000000e-09 8.599868000000e-01 1.534025000000e-09 8.599869000000e-01 1.534117000000e-09 8.578752000000e-01 1.534180000000e-09 8.565588000000e-01 1.534382000000e-09 8.532730000000e-01 1.534737000000e-09 8.494954000000e-01 1.535025000000e-09 8.484983000000e-01 1.535086000000e-09 8.492479000000e-01 1.535120000000e-09 8.496622000000e-01 1.535227000000e-09 8.507843000000e-01 1.535516000000e-09 8.530883000000e-01 1.535770000000e-09 8.547462000000e-01 1.536253000000e-09 8.571684000000e-01 1.537797000000e-09 8.613883000000e-01 1.540037000000e-09 8.622473000000e-01 1.542991000000e-09 8.615779000000e-01 1.546340000000e-09 8.608532000000e-01 1.549563000000e-09 8.604165000000e-01 1.553023000000e-09 8.601236000000e-01 1.556674000000e-09 8.600008000000e-01 1.561332000000e-09 8.599396000000e-01 1.564959000000e-09 8.599564000000e-01 1.568637000000e-09 8.599508000000e-01 1.572862000000e-09 8.599726000000e-01 1.576410000000e-09 8.599650000000e-01 1.580380000000e-09 8.599833000000e-01 1.584817000000e-09 8.599737000000e-01 1.588226000000e-09 8.599879000000e-01 1.592181000000e-09 8.599764000000e-01 1.595925000000e-09 8.599908000000e-01 1.599741000000e-09 8.599782000000e-01 1.604581000000e-09 8.599966000000e-01 1.606342000000e-09 8.599911000000e-01 1.608103000000e-09 8.599792000000e-01 1.611836000000e-09 8.599911000000e-01 1.616035000000e-09 8.599755000000e-01 1.619218000000e-09 8.599898000000e-01 1.623182000000e-09 8.599723000000e-01 1.626358000000e-09 8.599834000000e-01 1.629985000000e-09 8.599974000000e-01 1.634074000000e-09 8.600984000000e-01 1.638238000000e-09 8.601284000000e-01 1.643068000000e-09 8.601309000000e-01 1.648476000000e-09 8.599152000000e-01 1.653917000000e-09 8.592570000000e-01 1.658595000000e-09 8.583040000000e-01 1.665047000000e-09 8.558583000000e-01 1.668427000000e-09 8.560681000000e-01 1.674362000000e-09 8.715842000000e-01 1.678501000000e-09 8.914657000000e-01 1.684581000000e-09 9.048447000000e-01 1.686093000000e-09 8.963392000000e-01 1.687486000000e-09 8.836486000000e-01 1.691945000000e-09 7.798710000000e-01 1.695547000000e-09 6.397485000000e-01 1.700342000000e-09 4.292623000000e-01 1.704014000000e-09 2.910105000000e-01 1.707642000000e-09 1.886755000000e-01 1.712914000000e-09 1.027744000000e-01 1.717024000000e-09 6.918384000000e-02 1.722796000000e-09 4.110623000000e-02 1.724262000000e-09 3.634850000000e-02 1.725743000000e-09 3.165897000000e-02 1.730482000000e-09 1.845623000000e-02 1.734128000000e-09 1.107337000000e-02 1.739613000000e-09 4.717495000000e-03 1.743241000000e-09 2.670438000000e-03 1.746998000000e-09 1.474450000000e-03 1.752400000000e-09 6.102509000000e-04 1.756586000000e-09 3.179110000000e-04 1.762468000000e-09 1.272066000000e-04 1.764025000000e-09 1.040405000000e-04 1.765380000000e-09 8.619843000000e-05 1.769719000000e-09 4.852104000000e-05 1.773264000000e-09 3.289178000000e-05 1.778028000000e-09 2.047125000000e-05 1.781718000000e-09 1.516057000000e-05 1.785310000000e-09 1.172368000000e-05 1.790811000000e-09 8.874964000000e-06 1.794844000000e-09 7.924776000000e-06 1.800637000000e-09 7.053346000000e-06 1.802097000000e-09 6.933316000000e-06 1.803580000000e-09 6.821916000000e-06 1.808326000000e-09 6.578707000000e-06 1.811970000000e-09 6.463873000000e-06 1.817496000000e-09 6.347893000000e-06 1.821120000000e-09 6.305484000000e-06 1.824884000000e-09 6.283879000000e-06 1.830308000000e-09 6.268924000000e-06 1.834495000000e-09 6.263539000000e-06 1.840377000000e-09 6.255349000000e-06 1.841939000000e-09 6.254317000000e-06 1.843284000000e-09 6.253469000000e-06 1.847586000000e-09 6.251396000000e-06 1.851115000000e-09 6.250130000000e-06 1.855851000000e-09 6.249007000000e-06 1.859543000000e-09 6.248588000000e-06 1.863125000000e-09 6.248365000000e-06 1.868621000000e-09 6.248029000000e-06 1.872640000000e-09 6.247873000000e-06 1.878406000000e-09 6.247665000000e-06 1.879857000000e-09 6.247670000000e-06 1.881342000000e-09 6.247670000000e-06 1.886097000000e-09 6.247647000000e-06 1.889729000000e-09 6.247627000000e-06 1.895406000000e-09 6.247614000000e-06 1.899019000000e-09 6.247611000000e-06 1.902802000000e-09 6.247606000000e-06 1.908327000000e-09 6.247602000000e-06 1.912510000000e-09 6.247601000000e-06 1.918396000000e-09 6.247600000000e-06 1.923452000000e-09 6.247600000000e-06 1.928319000000e-09 6.247600000000e-06 1.933832000000e-09 6.247600000000e-06 1.937865000000e-09 6.247600000000e-06 1.941516000000e-09 6.247600000000e-06 1.947123000000e-09 6.247600000000e-06 1.951206000000e-09 6.247600000000e-06 1.957151000000e-09 6.247600000000e-06 1.962202000000e-09 6.247600000000e-06 1.967100000000e-09 6.247600000000e-06 1.968013000000e-09 6.247600000000e-06 1.969099000000e-09 6.247600000000e-06 1.972453000000e-09 6.247600000000e-06 1.975701000000e-09 6.247601000000e-06 1.979195000000e-09 6.247601000000e-06 1.983866000000e-09 6.247601000000e-06 1.987814000000e-09 6.247601000000e-06 1.993099000000e-09 6.247601000000e-06 1.998488000000e-09 6.247601000000e-06 2.003935000000e-09 6.247601000000e-06 2.004866000000e-09 6.247601000000e-06 2.005730000000e-09 6.247601000000e-06 2.008495000000e-09 6.247601000000e-06 2.013208000000e-09 6.247601000000e-06 2.016501000000e-09 6.247601000000e-06 2.021215000000e-09 6.247601000000e-06 2.025252000000e-09 6.247601000000e-06 2.030301000000e-09 6.247601000000e-06 2.035760000000e-09 6.247601000000e-06 2.040977000000e-09 6.247601000000e-06 2.042009000000e-09 6.247601000000e-06 2.042812000000e-09 6.247601000000e-06 2.045379000000e-09 6.247601000000e-06 2.049639000000e-09 6.247601000000e-06 2.053254000000e-09 6.247602000000e-06 2.056728000000e-09 6.247602000000e-06 2.062152000000e-09 6.247602000000e-06 2.066039000000e-09 6.247602000000e-06 2.071558000000e-09 6.247602000000e-06 2.076872000000e-09 6.247602000000e-06 2.078300000000e-09 6.247602000000e-06 2.079144000000e-09 6.247602000000e-06 2.081843000000e-09 6.247602000000e-06 2.085459000000e-09 6.247602000000e-06 2.089564000000e-09 6.247602000000e-06 2.093109000000e-09 6.247601000000e-06 2.096789000000e-09 6.247603000000e-06 2.101106000000e-09 6.247602000000e-06 2.105378000000e-09 6.247602000000e-06 2.110838000000e-09 6.247602000000e-06 2.112251000000e-09 6.247602000000e-06 2.113753000000e-09 6.247602000000e-06 2.118558000000e-09 6.247602000000e-06 2.122133000000e-09 6.247602000000e-06 2.129360000000e-09 6.247602000000e-06 2.132821000000e-09 6.247602000000e-06 2.136929000000e-09 6.247602000000e-06 2.139763000000e-09 6.247602000000e-06 2.142597000000e-09 6.247602000000e-06 2.147012000000e-09 6.247602000000e-06 2.152765000000e-09 6.247602000000e-06 2.154377000000e-09 6.247602000000e-06 2.155442000000e-09 6.247602000000e-06 2.158852000000e-09 6.247602000000e-06 2.162621000000e-09 6.247602000000e-06 2.166944000000e-09 6.247602000000e-06 2.170618000000e-09 6.247602000000e-06 2.174167000000e-09 6.247602000000e-06 2.179170000000e-09 6.247602000000e-06 2.183292000000e-09 6.247602000000e-06 2.188867000000e-09 6.247602000000e-06 2.190278000000e-09 6.247602000000e-06 2.191779000000e-09 6.247602000000e-06 2.196584000000e-09 6.247602000000e-06 2.200169000000e-09 6.247602000000e-06 2.207050000000e-09 6.247602000000e-06 2.210543000000e-09 6.247602000000e-06 2.214570000000e-09 6.247602000000e-06 2.217383000000e-09 6.247602000000e-06 2.220196000000e-09 6.247602000000e-06 2.224548000000e-09 6.247602000000e-06 2.230327000000e-09 6.247602000000e-06 2.231668000000e-09 6.247602000000e-06 2.232487000000e-09 6.247602000000e-06 2.235108000000e-09 6.247602000000e-06 2.238430000000e-09 6.247602000000e-06 2.242101000000e-09 6.247602000000e-06 2.245250000000e-09 6.247602000000e-06 2.248623000000e-09 6.247602000000e-06 2.252399000000e-09 6.247602000000e-06 2.256336000000e-09 6.247602000000e-06 2.261919000000e-09 6.247602000000e-06 2.264384000000e-09 6.247602000000e-06 2.265883000000e-09 6.247602000000e-06 2.270679000000e-09 6.247602000000e-06 2.277378000000e-09 6.247603000000e-06 2.283984000000e-09 6.247602000000e-06 2.291963000000e-09 6.247602000000e-06 2.303337000000e-09 6.247602000000e-06 2.323042000000e-09 6.247603000000e-06 2.352076000000e-09 6.247603000000e-06 2.407975000000e-09 6.247603000000e-06 2.543499000000e-09 6.247603000000e-06 2.778736000000e-09 6.247603000000e-06 3.128736000000e-09 6.247603000000e-06 3.478736000000e-09 6.247603000000e-06 3.828736000000e-09 6.247603000000e-06 4.076000000000e-09 6.247603000000e-06 4.076500000000e-09 2.037635000000e-02 4.077000000000e-09 4.006733000000e-02 4.077306000000e-09 3.904557000000e-02 4.077515000000e-09 3.824818000000e-02 4.078112000000e-09 3.570882000000e-02 4.079900000000e-09 2.849821000000e-02 4.082540000000e-09 1.954985000000e-02 4.086501000000e-09 1.040373000000e-02 4.092049000000e-09 3.783133000000e-03 4.100074000000e-09 6.728263000000e-04 4.112222000000e-09 -3.187678000000e-05 4.128358000000e-09 2.202217000000e-05 4.151784000000e-09 -4.243282000000e-06 4.181738000000e-09 1.638219000000e-05 4.223091000000e-09 -1.068683000000e-06 4.287381000000e-09 1.500046000000e-05 4.412795000000e-09 -6.962917000000e-07 4.639879000000e-09 1.497477000000e-05 4.989879000000e-09 -1.114701000000e-06 5.339879000000e-09 1.533522000000e-05 5.689879000000e-09 -1.415535000000e-06 6.039879000000e-09 1.562736000000e-05 6.389879000000e-09 -1.716623000000e-06 6.739879000000e-09 1.588208000000e-05 7.000000000000e-09 -2.006299000000e-06)
V_XOR_16 xor_16 0 PWL(0.000000000000e+00 6.995221000000e-06 1.000000000000e-12 6.997984000000e-06 2.000000000000e-12 7.000502000000e-06 5.200000000000e-12 7.006871000000e-06 1.544000000000e-11 7.014253000000e-06 4.820800000000e-11 7.014547000000e-06 1.530656000000e-10 7.014629000000e-06 4.886099000000e-10 7.014537000000e-06 8.386099000000e-10 7.014631000000e-06 9.995000000000e-10 7.014537000000e-06 9.996500000000e-10 7.014541000000e-06 1.000130000000e-09 7.014550000000e-06 1.000271000000e-09 7.014553000000e-06 1.000500000000e-09 7.014556000000e-06 1.000549000000e-09 7.014557000000e-06 1.000579000000e-09 7.014557000000e-06 1.000674000000e-09 7.014559000000e-06 1.000921000000e-09 7.014561000000e-06 1.001177000000e-09 7.014564000000e-06 1.001636000000e-09 7.014567000000e-06 1.002995000000e-09 7.014574000000e-06 1.004717000000e-09 7.014578000000e-06 1.007157000000e-09 7.014583000000e-06 1.009530000000e-09 7.014585000000e-06 1.012064000000e-09 7.014586000000e-06 1.014479000000e-09 7.014587000000e-06 1.016999000000e-09 7.014587000000e-06 1.019780000000e-09 7.014587000000e-06 1.023006000000e-09 7.014586000000e-06 1.025715000000e-09 7.014586000000e-06 1.028767000000e-09 7.014585000000e-06 1.031545000000e-09 7.014585000000e-06 1.034548000000e-09 7.014585000000e-06 1.037295000000e-09 7.014585000000e-06 1.040188000000e-09 7.014584000000e-06 1.042931000000e-09 7.014584000000e-06 1.046095000000e-09 7.014584000000e-06 1.049020000000e-09 7.014584000000e-06 1.051920000000e-09 7.014584000000e-06 1.055268000000e-09 7.014584000000e-06 1.057963000000e-09 7.014584000000e-06 1.059420000000e-09 7.014584000000e-06 1.060877000000e-09 7.014584000000e-06 1.063981000000e-09 7.014584000000e-06 1.066813000000e-09 7.014584000000e-06 1.069715000000e-09 7.014584000000e-06 1.073141000000e-09 7.014584000000e-06 1.075000000000e-09 7.014584000000e-06 1.075500000000e-09 -2.045888000000e-02 1.075834000000e-09 -3.391895000000e-02 1.076000000000e-09 -4.043047000000e-02 1.076266000000e-09 -3.910846000000e-02 1.076419000000e-09 -3.826786000000e-02 1.076822000000e-09 -3.580911000000e-02 1.078112000000e-09 -2.860478000000e-02 1.079915000000e-09 -2.077672000000e-02 1.082834000000e-09 -1.253812000000e-02 1.086452000000e-09 -6.732492000000e-03 1.089863000000e-09 -3.811583000000e-03 1.094093000000e-09 -1.921681000000e-03 1.097558000000e-09 -1.165445000000e-03 1.101264000000e-09 -7.065969000000e-04 1.105520000000e-09 -4.344228000000e-04 1.109056000000e-09 -2.959288000000e-04 1.112992000000e-09 -2.150839000000e-04 1.115807000000e-09 -1.673405000000e-04 1.118621000000e-09 -1.279798000000e-04 1.121942000000e-09 -1.058274000000e-04 1.125724000000e-09 -7.572437000000e-05 1.129501000000e-09 -6.325407000000e-05 1.133249000000e-09 -4.285626000000e-05 1.135809000000e-09 -3.587991000000e-05 1.138369000000e-09 -3.454717000000e-05 1.141791000000e-09 -2.268020000000e-05 1.145734000000e-09 -1.969639000000e-05 1.150017000000e-09 -1.008213000000e-05 1.153865000000e-09 -1.102566000000e-05 1.158361000000e-09 -4.749447000000e-06 1.161824000000e-09 -6.269400000000e-06 1.165535000000e-09 -1.363381000000e-06 1.169527000000e-09 -3.004000000000e-06 1.173109000000e-09 8.421522000000e-07 1.177056000000e-09 -9.417078000000e-07 1.179535000000e-09 1.080576000000e-07 1.182013000000e-09 2.831831000000e-06 1.185429000000e-09 9.489744000000e-07 1.189651000000e-09 3.474935000000e-06 1.193349000000e-09 2.230150000000e-06 1.197208000000e-09 4.177973000000e-06 1.200595000000e-09 2.903837000000e-06 1.204042000000e-09 4.370442000000e-06 1.207661000000e-09 3.378371000000e-06 1.212044000000e-09 4.811622000000e-06 1.215603000000e-09 3.987101000000e-06 1.219624000000e-09 5.079813000000e-06 1.222280000000e-09 5.068909000000e-06 1.224935000000e-09 4.475377000000e-06 1.228316000000e-09 5.352251000000e-06 1.229186000000e-09 5.237902000000e-06 1.230042000000e-09 5.195268000000e-06 1.232779000000e-09 6.109708000000e-06 1.235670000000e-09 6.042911000000e-06 1.238863000000e-09 6.018340000000e-06 1.243639000000e-09 5.931777000000e-06 1.246999000000e-09 5.993866000000e-06 1.250850000000e-09 5.921206000000e-06 1.255187000000e-09 5.993340000000e-06 1.258822000000e-09 5.925993000000e-06 1.259631000000e-09 5.957636000000e-06 1.260438000000e-09 5.962809000000e-06 1.263021000000e-09 5.963061000000e-06 1.265957000000e-09 5.970297000000e-06 1.269137000000e-09 5.948698000000e-06 1.273131000000e-09 5.977212000000e-06 1.276658000000e-09 5.965058000000e-06 1.280195000000e-09 5.964353000000e-06 1.284359000000e-09 5.980310000000e-06 1.288216000000e-09 6.273057000000e-06 1.291735000000e-09 5.587039000000e-06 1.292574000000e-09 5.628983000000e-06 1.293423000000e-09 5.676877000000e-06 1.296139000000e-09 5.708629000000e-06 1.299136000000e-09 5.769287000000e-06 1.302736000000e-09 5.713537000000e-06 1.306959000000e-09 8.420680000000e-06 1.310392000000e-09 3.028737000000e-05 1.314112000000e-09 -3.878373000000e-06 1.317424000000e-09 -2.653551000000e-05 1.320972000000e-09 -6.449893000000e-05 1.324632000000e-09 -1.265988000000e-04 1.327145000000e-09 1.308411000000e-05 1.329658000000e-09 3.012201000000e-04 1.333049000000e-09 1.000386000000e-03 1.337028000000e-09 1.164160000000e-03 1.341293000000e-09 -3.468812000000e-03 1.345153000000e-09 -1.420066000000e-02 1.349994000000e-09 -1.555424000000e-02 1.353616000000e-09 2.360977000000e-02 1.357116000000e-09 1.071102000000e-01 1.357983000000e-09 1.319773000000e-01 1.358962000000e-09 1.596875000000e-01 1.362092000000e-09 2.395193000000e-01 1.364885000000e-09 2.997495000000e-01 1.369987000000e-09 4.104788000000e-01 1.373500000000e-09 4.934937000000e-01 1.377230000000e-09 5.778584000000e-01 1.381288000000e-09 6.526521000000e-01 1.384815000000e-09 6.998062000000e-01 1.388662000000e-09 7.359742000000e-01 1.389532000000e-09 7.422095000000e-01 1.390483000000e-09 7.487449000000e-01 1.393528000000e-09 7.668888000000e-01 1.396267000000e-09 7.810338000000e-01 1.399530000000e-09 7.965653000000e-01 1.403009000000e-09 8.109468000000e-01 1.406745000000e-09 8.233494000000e-01 1.410579000000e-09 8.329579000000e-01 1.413057000000e-09 8.376883000000e-01 1.415535000000e-09 8.412556000000e-01 1.418933000000e-09 8.449892000000e-01 1.419781000000e-09 8.457534000000e-01 1.420563000000e-09 8.464396000000e-01 1.423064000000e-09 8.484144000000e-01 1.426220000000e-09 8.504681000000e-01 1.429627000000e-09 8.522021000000e-01 1.432942000000e-09 8.534642000000e-01 1.436511000000e-09 8.544583000000e-01 1.439973000000e-09 8.552426000000e-01 1.444113000000e-09 8.561123000000e-01 1.447667000000e-09 8.567784000000e-01 1.448597000000e-09 8.569326000000e-01 1.449278000000e-09 8.570439000000e-01 1.451458000000e-09 8.573778000000e-01 1.454984000000e-09 8.578556000000e-01 1.458241000000e-09 8.582379000000e-01 1.461761000000e-09 8.585940000000e-01 1.465886000000e-09 8.589394000000e-01 1.469389000000e-09 8.591756000000e-01 1.472794000000e-09 8.593604000000e-01 1.475276000000e-09 8.594720000000e-01 1.477758000000e-09 8.595641000000e-01 1.479095000000e-09 8.596053000000e-01 1.479882000000e-09 8.596289000000e-01 1.482402000000e-09 8.596956000000e-01 1.485321000000e-09 8.597584000000e-01 1.488790000000e-09 8.598165000000e-01 1.492381000000e-09 8.598617000000e-01 1.496661000000e-09 8.599007000000e-01 1.500576000000e-09 8.599259000000e-01 1.504103000000e-09 8.599424000000e-01 1.508121000000e-09 8.599559000000e-01 1.509046000000e-09 8.599583000000e-01 1.509764000000e-09 8.599601000000e-01 1.512062000000e-09 8.599651000000e-01 1.514727000000e-09 8.599698000000e-01 1.518391000000e-09 8.599747000000e-01 1.521668000000e-09 8.599780000000e-01 1.525243000000e-09 8.599806000000e-01 1.529365000000e-09 8.599827000000e-01 1.532875000000e-09 8.599840000000e-01 1.534025000000e-09 8.599843000000e-01 1.534117000000e-09 8.578726000000e-01 1.534180000000e-09 8.565563000000e-01 1.534382000000e-09 8.532705000000e-01 1.534737000000e-09 8.494929000000e-01 1.535025000000e-09 8.484959000000e-01 1.535086000000e-09 8.492455000000e-01 1.535120000000e-09 8.496598000000e-01 1.535227000000e-09 8.507819000000e-01 1.535516000000e-09 8.530860000000e-01 1.535770000000e-09 8.547440000000e-01 1.536253000000e-09 8.571662000000e-01 1.537797000000e-09 8.613863000000e-01 1.540037000000e-09 8.622458000000e-01 1.542991000000e-09 8.615767000000e-01 1.546340000000e-09 8.608523000000e-01 1.549563000000e-09 8.604158000000e-01 1.553023000000e-09 8.601232000000e-01 1.556674000000e-09 8.600005000000e-01 1.561332000000e-09 8.599394000000e-01 1.564959000000e-09 8.599563000000e-01 1.568637000000e-09 8.599507000000e-01 1.572862000000e-09 8.599725000000e-01 1.576410000000e-09 8.599650000000e-01 1.580380000000e-09 8.599833000000e-01 1.584817000000e-09 8.599737000000e-01 1.588226000000e-09 8.599879000000e-01 1.592181000000e-09 8.599759000000e-01 1.595925000000e-09 8.599902000000e-01 1.599741000000e-09 8.599776000000e-01 1.604581000000e-09 8.599975000000e-01 1.606342000000e-09 8.599923000000e-01 1.608103000000e-09 8.599804000000e-01 1.611836000000e-09 8.599943000000e-01 1.616035000000e-09 8.599800000000e-01 1.619218000000e-09 8.599936000000e-01 1.623182000000e-09 8.599789000000e-01 1.626358000000e-09 8.599932000000e-01 1.629985000000e-09 8.599790000000e-01 1.634074000000e-09 8.599938000000e-01 1.638238000000e-09 8.599794000000e-01 1.643068000000e-09 8.599923000000e-01 1.648476000000e-09 8.599772000000e-01 1.653917000000e-09 8.599891000000e-01 1.658595000000e-09 8.599743000000e-01 1.665047000000e-09 8.599850000000e-01 1.668427000000e-09 8.599916000000e-01 1.674362000000e-09 8.601211000000e-01 1.678501000000e-09 8.601333000000e-01 1.684581000000e-09 8.600849000000e-01 1.686093000000e-09 8.600175000000e-01 1.687486000000e-09 8.599335000000e-01 1.691945000000e-09 8.593780000000e-01 1.695547000000e-09 8.587496000000e-01 1.700342000000e-09 8.574716000000e-01 1.704014000000e-09 8.558122000000e-01 1.707642000000e-09 8.563306000000e-01 1.712914000000e-09 8.701110000000e-01 1.717024000000e-09 8.896549000000e-01 1.722796000000e-09 9.070346000000e-01 1.724262000000e-09 9.026045000000e-01 1.725743000000e-09 8.932404000000e-01 1.730482000000e-09 7.938593000000e-01 1.734128000000e-09 6.553979000000e-01 1.739613000000e-09 4.167893000000e-01 1.743241000000e-09 2.819917000000e-01 1.746998000000e-09 1.794409000000e-01 1.752400000000e-09 9.711030000000e-02 1.756586000000e-09 6.532276000000e-02 1.762468000000e-09 3.850173000000e-02 1.764025000000e-09 3.362428000000e-02 1.765380000000e-09 2.946304000000e-02 1.769719000000e-09 1.777014000000e-02 1.773264000000e-09 1.081448000000e-02 1.778028000000e-09 5.214767000000e-03 1.781718000000e-09 2.932634000000e-03 1.785310000000e-09 1.666870000000e-03 1.790811000000e-09 6.763561000000e-04 1.794844000000e-09 3.611543000000e-04 1.800637000000e-09 1.455738000000e-04 1.802097000000e-09 1.204076000000e-04 1.803580000000e-09 9.766113000000e-05 1.808326000000e-09 5.118461000000e-05 1.811970000000e-09 3.376543000000e-05 1.817496000000e-09 1.973089000000e-05 1.821120000000e-09 1.464672000000e-05 1.824884000000e-09 1.125157000000e-05 1.830308000000e-09 8.845869000000e-06 1.834495000000e-09 7.650001000000e-06 1.840377000000e-09 6.941541000000e-06 1.841939000000e-09 6.828013000000e-06 1.843284000000e-09 6.739521000000e-06 1.847586000000e-09 6.537554000000e-06 1.851115000000e-09 6.431212000000e-06 1.855851000000e-09 6.329689000000e-06 1.859543000000e-09 6.285443000000e-06 1.863125000000e-09 6.261751000000e-06 1.868621000000e-09 6.244228000000e-06 1.872640000000e-09 6.240391000000e-06 1.878406000000e-09 6.230302000000e-06 1.879857000000e-09 6.229444000000e-06 1.881342000000e-09 6.228547000000e-06 1.886097000000e-09 6.226284000000e-06 1.889729000000e-09 6.224942000000e-06 1.895406000000e-09 6.223621000000e-06 1.899019000000e-09 6.223258000000e-06 1.902802000000e-09 6.223029000000e-06 1.908327000000e-09 6.222699000000e-06 1.912510000000e-09 6.222534000000e-06 1.918396000000e-09 6.222381000000e-06 1.923452000000e-09 6.222367000000e-06 1.928319000000e-09 6.222342000000e-06 1.933832000000e-09 6.222327000000e-06 1.937865000000e-09 6.222396000000e-06 1.941516000000e-09 6.222293000000e-06 1.947123000000e-09 6.222300000000e-06 1.951206000000e-09 6.222304000000e-06 1.957151000000e-09 6.222311000000e-06 1.962202000000e-09 6.222312000000e-06 1.967100000000e-09 6.222312000000e-06 1.968013000000e-09 6.222312000000e-06 1.969099000000e-09 6.222312000000e-06 1.972453000000e-09 6.222312000000e-06 1.975701000000e-09 6.222313000000e-06 1.979195000000e-09 6.222313000000e-06 1.983866000000e-09 6.222313000000e-06 1.987814000000e-09 6.222313000000e-06 1.993099000000e-09 6.222313000000e-06 1.998488000000e-09 6.222313000000e-06 2.003935000000e-09 6.222313000000e-06 2.004866000000e-09 6.222313000000e-06 2.005730000000e-09 6.222313000000e-06 2.008495000000e-09 6.222313000000e-06 2.013208000000e-09 6.222313000000e-06 2.016501000000e-09 6.222313000000e-06 2.021215000000e-09 6.222313000000e-06 2.025252000000e-09 6.222313000000e-06 2.030301000000e-09 6.222313000000e-06 2.035760000000e-09 6.222313000000e-06 2.040977000000e-09 6.222313000000e-06 2.042009000000e-09 6.222313000000e-06 2.042812000000e-09 6.222313000000e-06 2.045379000000e-09 6.222313000000e-06 2.049639000000e-09 6.222313000000e-06 2.053254000000e-09 6.222314000000e-06 2.056728000000e-09 6.222314000000e-06 2.062152000000e-09 6.222314000000e-06 2.066039000000e-09 6.222314000000e-06 2.071558000000e-09 6.222314000000e-06 2.076872000000e-09 6.222314000000e-06 2.078300000000e-09 6.222314000000e-06 2.079144000000e-09 6.222314000000e-06 2.081843000000e-09 6.222314000000e-06 2.085459000000e-09 6.222314000000e-06 2.089564000000e-09 6.222314000000e-06 2.093109000000e-09 6.222314000000e-06 2.096789000000e-09 6.222314000000e-06 2.101106000000e-09 6.222314000000e-06 2.105378000000e-09 6.222314000000e-06 2.110838000000e-09 6.222314000000e-06 2.112251000000e-09 6.222314000000e-06 2.113753000000e-09 6.222314000000e-06 2.118558000000e-09 6.222314000000e-06 2.122133000000e-09 6.222314000000e-06 2.129360000000e-09 6.222314000000e-06 2.132821000000e-09 6.222314000000e-06 2.136929000000e-09 6.222314000000e-06 2.139763000000e-09 6.222314000000e-06 2.142597000000e-09 6.222314000000e-06 2.147012000000e-09 6.222314000000e-06 2.152765000000e-09 6.222314000000e-06 2.154377000000e-09 6.222314000000e-06 2.155442000000e-09 6.222314000000e-06 2.158852000000e-09 6.222314000000e-06 2.162621000000e-09 6.222314000000e-06 2.166944000000e-09 6.222314000000e-06 2.170618000000e-09 6.222314000000e-06 2.174167000000e-09 6.222314000000e-06 2.179170000000e-09 6.222314000000e-06 2.183292000000e-09 6.222314000000e-06 2.188867000000e-09 6.222314000000e-06 2.190278000000e-09 6.222314000000e-06 2.191779000000e-09 6.222314000000e-06 2.196584000000e-09 6.222314000000e-06 2.200169000000e-09 6.222314000000e-06 2.207050000000e-09 6.222314000000e-06 2.210543000000e-09 6.222314000000e-06 2.214570000000e-09 6.222314000000e-06 2.217383000000e-09 6.222314000000e-06 2.220196000000e-09 6.222314000000e-06 2.224548000000e-09 6.222314000000e-06 2.230327000000e-09 6.222314000000e-06 2.231668000000e-09 6.222314000000e-06 2.232487000000e-09 6.222314000000e-06 2.235108000000e-09 6.222314000000e-06 2.238430000000e-09 6.222314000000e-06 2.242101000000e-09 6.222314000000e-06 2.245250000000e-09 6.222314000000e-06 2.248623000000e-09 6.222314000000e-06 2.252399000000e-09 6.222314000000e-06 2.256336000000e-09 6.222314000000e-06 2.261919000000e-09 6.222314000000e-06 2.264384000000e-09 6.222314000000e-06 2.265883000000e-09 6.222314000000e-06 2.270679000000e-09 6.222314000000e-06 2.277378000000e-09 6.222315000000e-06 2.283984000000e-09 6.222314000000e-06 2.291963000000e-09 6.222314000000e-06 2.303337000000e-09 6.222314000000e-06 2.323042000000e-09 6.222315000000e-06 2.352076000000e-09 6.222315000000e-06 2.407975000000e-09 6.222315000000e-06 2.543499000000e-09 6.222315000000e-06 2.778736000000e-09 6.222315000000e-06 3.128736000000e-09 6.222315000000e-06 3.478736000000e-09 6.222315000000e-06 3.828736000000e-09 6.222315000000e-06 4.076000000000e-09 6.222315000000e-06 4.076500000000e-09 2.037633000000e-02 4.077000000000e-09 4.006731000000e-02 4.077306000000e-09 3.904554000000e-02 4.077515000000e-09 3.824816000000e-02 4.078112000000e-09 3.570879000000e-02 4.079900000000e-09 2.849820000000e-02 4.082540000000e-09 1.954984000000e-02 4.086501000000e-09 1.040372000000e-02 4.092049000000e-09 3.783130000000e-03 4.100074000000e-09 6.728259000000e-04 4.112222000000e-09 -3.187675000000e-05 4.128358000000e-09 2.202216000000e-05 4.151784000000e-09 -4.243286000000e-06 4.181738000000e-09 1.638219000000e-05 4.223091000000e-09 -1.068694000000e-06 4.287381000000e-09 1.500046000000e-05 4.412795000000e-09 -6.963036000000e-07 4.639879000000e-09 1.497477000000e-05 4.989879000000e-09 -1.114713000000e-06 5.339879000000e-09 1.533521000000e-05 5.689879000000e-09 -1.415547000000e-06 6.039879000000e-09 1.562735000000e-05 6.389879000000e-09 -1.716634000000e-06 6.739879000000e-09 1.588207000000e-05 7.000000000000e-09 -2.006310000000e-06)
V_XOR_17 xor_17 0 PWL(0.000000000000e+00 6.995221000000e-06 1.000000000000e-12 6.997984000000e-06 2.000000000000e-12 7.000502000000e-06 5.200000000000e-12 7.006871000000e-06 1.544000000000e-11 7.014253000000e-06 4.820800000000e-11 7.014547000000e-06 1.530656000000e-10 7.014629000000e-06 4.886099000000e-10 7.014537000000e-06 8.386099000000e-10 7.014631000000e-06 9.995000000000e-10 7.014537000000e-06 9.996500000000e-10 7.014541000000e-06 1.000130000000e-09 7.014550000000e-06 1.000271000000e-09 7.014553000000e-06 1.000500000000e-09 7.014556000000e-06 1.000549000000e-09 7.014557000000e-06 1.000579000000e-09 7.014557000000e-06 1.000674000000e-09 7.014559000000e-06 1.000921000000e-09 7.014561000000e-06 1.001177000000e-09 7.014564000000e-06 1.001636000000e-09 7.014567000000e-06 1.002995000000e-09 7.014574000000e-06 1.004717000000e-09 7.014578000000e-06 1.007157000000e-09 7.014583000000e-06 1.009530000000e-09 7.014585000000e-06 1.012064000000e-09 7.014586000000e-06 1.014479000000e-09 7.014587000000e-06 1.016999000000e-09 7.014587000000e-06 1.019780000000e-09 7.014587000000e-06 1.023006000000e-09 7.014586000000e-06 1.025715000000e-09 7.014586000000e-06 1.028767000000e-09 7.014585000000e-06 1.031545000000e-09 7.014585000000e-06 1.034548000000e-09 7.014585000000e-06 1.037295000000e-09 7.014585000000e-06 1.040188000000e-09 7.014584000000e-06 1.042931000000e-09 7.014584000000e-06 1.046095000000e-09 7.014584000000e-06 1.049020000000e-09 7.014584000000e-06 1.051920000000e-09 7.014584000000e-06 1.055268000000e-09 7.014584000000e-06 1.057963000000e-09 7.014584000000e-06 1.059420000000e-09 7.014584000000e-06 1.060877000000e-09 7.014584000000e-06 1.063981000000e-09 7.014584000000e-06 1.066813000000e-09 7.014584000000e-06 1.069715000000e-09 7.014584000000e-06 1.073141000000e-09 7.014584000000e-06 1.075000000000e-09 7.014584000000e-06 1.075500000000e-09 -2.045888000000e-02 1.075834000000e-09 -3.391895000000e-02 1.076000000000e-09 -4.043047000000e-02 1.076266000000e-09 -3.910846000000e-02 1.076419000000e-09 -3.826786000000e-02 1.076822000000e-09 -3.580911000000e-02 1.078112000000e-09 -2.860478000000e-02 1.079915000000e-09 -2.077672000000e-02 1.082834000000e-09 -1.253812000000e-02 1.086452000000e-09 -6.732492000000e-03 1.089863000000e-09 -3.811583000000e-03 1.094093000000e-09 -1.921681000000e-03 1.097558000000e-09 -1.165445000000e-03 1.101264000000e-09 -7.065969000000e-04 1.105520000000e-09 -4.344228000000e-04 1.109056000000e-09 -2.959288000000e-04 1.112992000000e-09 -2.150839000000e-04 1.115807000000e-09 -1.673405000000e-04 1.118621000000e-09 -1.279798000000e-04 1.121942000000e-09 -1.058274000000e-04 1.125724000000e-09 -7.572437000000e-05 1.129501000000e-09 -6.325407000000e-05 1.133249000000e-09 -4.285626000000e-05 1.135809000000e-09 -3.587991000000e-05 1.138369000000e-09 -3.454717000000e-05 1.141791000000e-09 -2.268020000000e-05 1.145734000000e-09 -1.969639000000e-05 1.150017000000e-09 -1.008213000000e-05 1.153865000000e-09 -1.102566000000e-05 1.158361000000e-09 -4.749447000000e-06 1.161824000000e-09 -6.269400000000e-06 1.165535000000e-09 -1.363381000000e-06 1.169527000000e-09 -3.004000000000e-06 1.173109000000e-09 8.421522000000e-07 1.177056000000e-09 -9.417078000000e-07 1.179535000000e-09 1.080576000000e-07 1.182013000000e-09 2.831831000000e-06 1.185429000000e-09 9.489744000000e-07 1.189651000000e-09 3.474935000000e-06 1.193349000000e-09 2.230150000000e-06 1.197208000000e-09 4.177973000000e-06 1.200595000000e-09 2.903837000000e-06 1.204042000000e-09 4.370442000000e-06 1.207661000000e-09 3.378371000000e-06 1.212044000000e-09 4.811622000000e-06 1.215603000000e-09 3.987101000000e-06 1.219624000000e-09 5.079813000000e-06 1.222280000000e-09 5.068909000000e-06 1.224935000000e-09 4.475377000000e-06 1.228316000000e-09 5.352252000000e-06 1.229186000000e-09 5.237903000000e-06 1.230042000000e-09 5.195261000000e-06 1.232779000000e-09 6.109705000000e-06 1.235670000000e-09 6.042910000000e-06 1.238863000000e-09 6.018342000000e-06 1.243639000000e-09 5.931768000000e-06 1.246999000000e-09 5.993830000000e-06 1.250850000000e-09 5.921387000000e-06 1.255187000000e-09 5.993012000000e-06 1.258822000000e-09 5.926258000000e-06 1.259631000000e-09 5.957746000000e-06 1.260438000000e-09 5.962808000000e-06 1.263021000000e-09 5.962825000000e-06 1.265957000000e-09 5.965606000000e-06 1.269137000000e-09 5.963087000000e-06 1.273131000000e-09 5.966761000000e-06 1.276658000000e-09 5.964508000000e-06 1.280195000000e-09 5.967598000000e-06 1.284359000000e-09 5.966340000000e-06 1.288216000000e-09 5.971315000000e-06 1.291735000000e-09 5.955521000000e-06 1.292574000000e-09 5.964328000000e-06 1.293423000000e-09 5.970519000000e-06 1.296139000000e-09 5.971100000000e-06 1.299136000000e-09 5.969662000000e-06 1.302736000000e-09 5.967549000000e-06 1.306959000000e-09 5.992459000000e-06 1.310392000000e-09 6.300340000000e-06 1.314112000000e-09 5.528149000000e-06 1.317424000000e-09 5.683438000000e-06 1.320972000000e-09 5.783740000000e-06 1.324632000000e-09 5.751285000000e-06 1.327145000000e-09 7.241569000000e-06 1.329658000000e-09 9.963426000000e-06 1.333049000000e-09 2.856278000000e-05 1.337028000000e-09 9.420566000000e-06 1.341293000000e-09 -3.621293000000e-05 1.345153000000e-09 -1.024750000000e-04 1.349994000000e-09 1.848174000000e-04 1.353616000000e-09 8.666316000000e-04 1.357116000000e-09 1.371890000000e-03 1.357983000000e-09 1.282385000000e-03 1.358962000000e-09 9.961368000000e-04 1.362092000000e-09 -2.693197000000e-03 1.364885000000e-09 -9.465192000000e-03 1.369987000000e-09 -2.033282000000e-02 1.373500000000e-09 -3.501240000000e-04 1.377230000000e-09 7.412226000000e-02 1.381288000000e-09 1.852414000000e-01 1.384815000000e-09 2.704911000000e-01 1.388662000000e-09 3.516729000000e-01 1.389532000000e-09 3.706276000000e-01 1.390483000000e-09 3.917444000000e-01 1.393528000000e-09 4.624709000000e-01 1.396267000000e-09 5.269722000000e-01 1.399530000000e-09 5.975450000000e-01 1.403009000000e-09 6.585076000000e-01 1.406745000000e-09 7.062692000000e-01 1.410579000000e-09 7.403486000000e-01 1.413057000000e-09 7.575199000000e-01 1.415535000000e-09 7.708752000000e-01 1.418933000000e-09 7.876928000000e-01 1.419781000000e-09 7.916330000000e-01 1.420563000000e-09 7.952182000000e-01 1.423064000000e-09 8.059033000000e-01 1.426220000000e-09 8.174656000000e-01 1.429627000000e-09 8.275097000000e-01 1.432942000000e-09 8.349450000000e-01 1.436511000000e-09 8.406666000000e-01 1.439973000000e-09 8.446182000000e-01 1.444113000000e-09 8.481689000000e-01 1.447667000000e-09 8.505158000000e-01 1.448597000000e-09 8.510176000000e-01 1.449278000000e-09 8.513755000000e-01 1.451458000000e-09 8.523952000000e-01 1.454984000000e-09 8.536721000000e-01 1.458241000000e-09 8.545398000000e-01 1.461761000000e-09 8.553309000000e-01 1.465886000000e-09 8.561914000000e-01 1.469389000000e-09 8.568378000000e-01 1.472794000000e-09 8.573756000000e-01 1.475276000000e-09 8.577219000000e-01 1.477758000000e-09 8.580295000000e-01 1.479095000000e-09 8.581790000000e-01 1.479882000000e-09 8.582656000000e-01 1.482402000000e-09 8.585232000000e-01 1.485321000000e-09 8.587850000000e-01 1.488790000000e-09 8.590473000000e-01 1.492381000000e-09 8.592674000000e-01 1.496661000000e-09 8.594706000000e-01 1.500576000000e-09 8.596097000000e-01 1.504103000000e-09 8.597046000000e-01 1.508121000000e-09 8.597854000000e-01 1.509046000000e-09 8.597999000000e-01 1.509764000000e-09 8.598109000000e-01 1.512062000000e-09 8.598422000000e-01 1.514727000000e-09 8.598719000000e-01 1.518391000000e-09 8.599033000000e-01 1.521668000000e-09 8.599243000000e-01 1.525243000000e-09 8.599413000000e-01 1.529365000000e-09 8.599555000000e-01 1.532875000000e-09 8.599640000000e-01 1.534025000000e-09 8.599663000000e-01 1.534117000000e-09 8.578552000000e-01 1.534180000000e-09 8.565386000000e-01 1.534382000000e-09 8.532533000000e-01 1.534737000000e-09 8.494758000000e-01 1.535025000000e-09 8.484792000000e-01 1.535086000000e-09 8.492288000000e-01 1.535120000000e-09 8.496431000000e-01 1.535227000000e-09 8.507653000000e-01 1.535516000000e-09 8.530698000000e-01 1.535770000000e-09 8.547281000000e-01 1.536253000000e-09 8.571510000000e-01 1.537797000000e-09 8.613727000000e-01 1.540037000000e-09 8.622346000000e-01 1.542991000000e-09 8.615684000000e-01 1.546340000000e-09 8.608463000000e-01 1.549563000000e-09 8.604115000000e-01 1.553023000000e-09 8.601201000000e-01 1.556674000000e-09 8.599985000000e-01 1.561332000000e-09 8.599381000000e-01 1.564959000000e-09 8.599554000000e-01 1.568637000000e-09 8.599500000000e-01 1.572862000000e-09 8.599721000000e-01 1.576410000000e-09 8.599646000000e-01 1.580380000000e-09 8.599831000000e-01 1.584817000000e-09 8.599736000000e-01 1.588226000000e-09 8.599878000000e-01 1.592181000000e-09 8.599759000000e-01 1.595925000000e-09 8.599902000000e-01 1.599741000000e-09 8.599775000000e-01 1.604581000000e-09 8.599975000000e-01 1.606342000000e-09 8.599923000000e-01 1.608103000000e-09 8.599804000000e-01 1.611836000000e-09 8.599943000000e-01 1.616035000000e-09 8.599800000000e-01 1.619218000000e-09 8.599936000000e-01 1.623182000000e-09 8.599789000000e-01 1.626358000000e-09 8.599932000000e-01 1.629985000000e-09 8.599786000000e-01 1.634074000000e-09 8.599931000000e-01 1.638238000000e-09 8.599787000000e-01 1.643068000000e-09 8.599932000000e-01 1.648476000000e-09 8.599789000000e-01 1.653917000000e-09 8.599935000000e-01 1.658595000000e-09 8.599790000000e-01 1.665047000000e-09 8.599935000000e-01 1.668427000000e-09 8.599792000000e-01 1.674362000000e-09 8.600044000000e-01 1.678501000000e-09 8.599828000000e-01 1.684581000000e-09 8.599954000000e-01 1.686093000000e-09 8.599872000000e-01 1.687486000000e-09 8.599862000000e-01 1.691945000000e-09 8.599836000000e-01 1.695547000000e-09 8.599835000000e-01 1.700342000000e-09 8.599820000000e-01 1.704014000000e-09 8.599779000000e-01 1.707642000000e-09 8.600040000000e-01 1.712914000000e-09 8.601006000000e-01 1.717024000000e-09 8.601384000000e-01 1.722796000000e-09 8.600952000000e-01 1.724262000000e-09 8.600520000000e-01 1.725743000000e-09 8.599785000000e-01 1.730482000000e-09 8.594333000000e-01 1.734128000000e-09 8.588091000000e-01 1.739613000000e-09 8.573075000000e-01 1.743241000000e-09 8.556799000000e-01 1.746998000000e-09 8.568289000000e-01 1.752400000000e-09 8.724178000000e-01 1.756586000000e-09 8.926387000000e-01 1.762468000000e-09 9.050625000000e-01 1.764025000000e-09 8.958537000000e-01 1.765380000000e-09 8.831888000000e-01 1.769719000000e-09 7.825679000000e-01 1.773264000000e-09 6.457942000000e-01 1.778028000000e-09 4.364681000000e-01 1.781718000000e-09 2.961531000000e-01 1.785310000000e-09 1.931510000000e-01 1.790811000000e-09 1.022981000000e-01 1.794844000000e-09 6.946884000000e-02 1.800637000000e-09 4.118607000000e-02 1.802097000000e-09 3.644843000000e-02 1.803580000000e-09 3.175289000000e-02 1.808326000000e-09 1.851668000000e-02 1.811970000000e-09 1.111750000000e-02 1.817496000000e-09 4.703373000000e-03 1.821120000000e-09 2.663445000000e-03 1.824884000000e-09 1.468991000000e-03 1.830308000000e-09 6.054652000000e-04 1.834495000000e-09 3.154382000000e-04 1.840377000000e-09 1.262895000000e-04 1.841939000000e-09 1.032202000000e-04 1.843284000000e-09 8.567091000000e-05 1.847586000000e-09 4.849160000000e-05 1.851115000000e-09 3.292475000000e-05 1.855851000000e-09 2.055188000000e-05 1.859543000000e-09 1.520865000000e-05 1.863125000000e-09 1.176394000000e-05 1.868621000000e-09 8.893686000000e-06 1.872640000000e-09 7.939573000000e-06 1.878406000000e-09 7.065128000000e-06 1.879857000000e-09 6.942790000000e-06 1.881342000000e-09 6.828778000000e-06 1.886097000000e-09 6.581647000000e-06 1.889729000000e-09 6.467665000000e-06 1.895406000000e-09 6.347911000000e-06 1.899019000000e-09 6.305504000000e-06 1.902802000000e-09 6.283901000000e-06 1.908327000000e-09 6.268859000000e-06 1.912510000000e-09 6.263558000000e-06 1.918396000000e-09 6.255475000000e-06 1.923452000000e-09 6.252408000000e-06 1.928319000000e-09 6.250544000000e-06 1.933832000000e-09 6.249215000000e-06 1.937865000000e-09 6.248669000000e-06 1.941516000000e-09 6.248628000000e-06 1.947123000000e-09 6.248158000000e-06 1.951206000000e-09 6.248140000000e-06 1.957151000000e-09 6.247818000000e-06 1.962202000000e-09 6.247959000000e-06 1.967100000000e-09 6.247791000000e-06 1.968013000000e-09 6.247870000000e-06 1.969099000000e-09 6.247862000000e-06 1.972453000000e-09 6.247850000000e-06 1.975701000000e-09 6.247847000000e-06 1.979195000000e-09 6.247845000000e-06 1.983866000000e-09 6.247837000000e-06 1.987814000000e-09 6.247837000000e-06 1.993099000000e-09 6.247836000000e-06 1.998488000000e-09 6.247836000000e-06 2.003935000000e-09 6.247835000000e-06 2.004866000000e-09 6.247835000000e-06 2.005730000000e-09 6.247835000000e-06 2.008495000000e-09 6.247835000000e-06 2.013208000000e-09 6.247835000000e-06 2.016501000000e-09 6.247835000000e-06 2.021215000000e-09 6.247835000000e-06 2.025252000000e-09 6.247835000000e-06 2.030301000000e-09 6.247835000000e-06 2.035760000000e-09 6.247835000000e-06 2.040977000000e-09 6.247835000000e-06 2.042009000000e-09 6.247835000000e-06 2.042812000000e-09 6.247835000000e-06 2.045379000000e-09 6.247835000000e-06 2.049639000000e-09 6.247835000000e-06 2.053254000000e-09 6.247835000000e-06 2.056728000000e-09 6.247835000000e-06 2.062152000000e-09 6.247835000000e-06 2.066039000000e-09 6.247835000000e-06 2.071558000000e-09 6.247793000000e-06 2.076872000000e-09 6.247879000000e-06 2.078300000000e-09 6.247862000000e-06 2.079144000000e-09 6.247853000000e-06 2.081843000000e-09 6.247841000000e-06 2.085459000000e-09 6.247837000000e-06 2.089564000000e-09 6.247836000000e-06 2.093109000000e-09 6.247835000000e-06 2.096789000000e-09 6.247835000000e-06 2.101106000000e-09 6.247835000000e-06 2.105378000000e-09 6.247835000000e-06 2.110838000000e-09 6.247835000000e-06 2.112251000000e-09 6.247835000000e-06 2.113753000000e-09 6.247835000000e-06 2.118558000000e-09 6.247835000000e-06 2.122133000000e-09 6.247835000000e-06 2.129360000000e-09 6.247835000000e-06 2.132821000000e-09 6.247835000000e-06 2.136929000000e-09 6.247835000000e-06 2.139763000000e-09 6.247835000000e-06 2.142597000000e-09 6.247835000000e-06 2.147012000000e-09 6.247835000000e-06 2.152765000000e-09 6.247835000000e-06 2.154377000000e-09 6.247835000000e-06 2.155442000000e-09 6.247835000000e-06 2.158852000000e-09 6.247836000000e-06 2.162621000000e-09 6.247836000000e-06 2.166944000000e-09 6.247836000000e-06 2.170618000000e-09 6.247836000000e-06 2.174167000000e-09 6.247836000000e-06 2.179170000000e-09 6.247836000000e-06 2.183292000000e-09 6.247836000000e-06 2.188867000000e-09 6.247836000000e-06 2.190278000000e-09 6.247836000000e-06 2.191779000000e-09 6.247836000000e-06 2.196584000000e-09 6.247836000000e-06 2.200169000000e-09 6.247836000000e-06 2.207050000000e-09 6.247836000000e-06 2.210543000000e-09 6.247836000000e-06 2.214570000000e-09 6.247836000000e-06 2.217383000000e-09 6.247836000000e-06 2.220196000000e-09 6.247836000000e-06 2.224548000000e-09 6.247836000000e-06 2.230327000000e-09 6.247836000000e-06 2.231668000000e-09 6.247836000000e-06 2.232487000000e-09 6.247836000000e-06 2.235108000000e-09 6.247836000000e-06 2.238430000000e-09 6.247836000000e-06 2.242101000000e-09 6.247836000000e-06 2.245250000000e-09 6.247836000000e-06 2.248623000000e-09 6.247836000000e-06 2.252399000000e-09 6.247836000000e-06 2.256336000000e-09 6.247836000000e-06 2.261919000000e-09 6.247836000000e-06 2.264384000000e-09 6.247836000000e-06 2.265883000000e-09 6.247836000000e-06 2.270679000000e-09 6.247836000000e-06 2.277378000000e-09 6.247836000000e-06 2.283984000000e-09 6.247836000000e-06 2.291963000000e-09 6.247836000000e-06 2.303337000000e-09 6.247836000000e-06 2.323042000000e-09 6.247836000000e-06 2.352076000000e-09 6.247836000000e-06 2.407975000000e-09 6.247836000000e-06 2.543499000000e-09 6.247836000000e-06 2.778736000000e-09 6.247836000000e-06 3.128736000000e-09 6.247836000000e-06 3.478736000000e-09 6.247836000000e-06 3.828736000000e-09 6.247836000000e-06 4.076000000000e-09 6.247836000000e-06 4.076500000000e-09 2.037635000000e-02 4.077000000000e-09 4.006733000000e-02 4.077306000000e-09 3.904557000000e-02 4.077515000000e-09 3.824818000000e-02 4.078112000000e-09 3.570882000000e-02 4.079900000000e-09 2.849821000000e-02 4.082540000000e-09 1.954985000000e-02 4.086501000000e-09 1.040373000000e-02 4.092049000000e-09 3.783133000000e-03 4.100074000000e-09 6.728264000000e-04 4.112222000000e-09 -3.187679000000e-05 4.128358000000e-09 2.202218000000e-05 4.151784000000e-09 -4.243289000000e-06 4.181738000000e-09 1.638220000000e-05 4.223091000000e-09 -1.068686000000e-06 4.287381000000e-09 1.500047000000e-05 4.412795000000e-09 -6.962928000000e-07 4.639879000000e-09 1.497478000000e-05 4.989879000000e-09 -1.114702000000e-06 5.339879000000e-09 1.533523000000e-05 5.689879000000e-09 -1.415536000000e-06 6.039879000000e-09 1.562737000000e-05 6.389879000000e-09 -1.716624000000e-06 6.739879000000e-09 1.588209000000e-05 7.000000000000e-09 -2.006300000000e-06)
V_XOR_18 xor_18 0 PWL(0.000000000000e+00 6.995221000000e-06 1.000000000000e-12 6.997984000000e-06 2.000000000000e-12 7.000502000000e-06 5.200000000000e-12 7.006871000000e-06 1.544000000000e-11 7.014253000000e-06 4.820800000000e-11 7.014547000000e-06 1.530656000000e-10 7.014629000000e-06 4.886099000000e-10 7.014537000000e-06 8.386099000000e-10 7.014631000000e-06 9.995000000000e-10 7.014537000000e-06 9.996500000000e-10 7.014541000000e-06 1.000130000000e-09 7.014550000000e-06 1.000271000000e-09 7.014553000000e-06 1.000500000000e-09 7.014556000000e-06 1.000549000000e-09 7.014557000000e-06 1.000579000000e-09 7.014557000000e-06 1.000674000000e-09 7.014559000000e-06 1.000921000000e-09 7.014561000000e-06 1.001177000000e-09 7.014564000000e-06 1.001636000000e-09 7.014567000000e-06 1.002995000000e-09 7.014574000000e-06 1.004717000000e-09 7.014578000000e-06 1.007157000000e-09 7.014583000000e-06 1.009530000000e-09 7.014585000000e-06 1.012064000000e-09 7.014586000000e-06 1.014479000000e-09 7.014587000000e-06 1.016999000000e-09 7.014587000000e-06 1.019780000000e-09 7.014587000000e-06 1.023006000000e-09 7.014586000000e-06 1.025715000000e-09 7.014586000000e-06 1.028767000000e-09 7.014585000000e-06 1.031545000000e-09 7.014585000000e-06 1.034548000000e-09 7.014585000000e-06 1.037295000000e-09 7.014585000000e-06 1.040188000000e-09 7.014584000000e-06 1.042931000000e-09 7.014584000000e-06 1.046095000000e-09 7.014584000000e-06 1.049020000000e-09 7.014584000000e-06 1.051920000000e-09 7.014584000000e-06 1.055268000000e-09 7.014584000000e-06 1.057963000000e-09 7.014584000000e-06 1.059420000000e-09 7.014584000000e-06 1.060877000000e-09 7.014584000000e-06 1.063981000000e-09 7.014584000000e-06 1.066813000000e-09 7.014584000000e-06 1.069715000000e-09 7.014584000000e-06 1.073141000000e-09 7.014584000000e-06 1.075000000000e-09 7.014584000000e-06 1.075500000000e-09 -2.045888000000e-02 1.075834000000e-09 -3.391895000000e-02 1.076000000000e-09 -4.043047000000e-02 1.076266000000e-09 -3.910846000000e-02 1.076419000000e-09 -3.826786000000e-02 1.076822000000e-09 -3.580911000000e-02 1.078112000000e-09 -2.860478000000e-02 1.079915000000e-09 -2.077672000000e-02 1.082834000000e-09 -1.253812000000e-02 1.086452000000e-09 -6.732492000000e-03 1.089863000000e-09 -3.811583000000e-03 1.094093000000e-09 -1.921681000000e-03 1.097558000000e-09 -1.165445000000e-03 1.101264000000e-09 -7.065969000000e-04 1.105520000000e-09 -4.344228000000e-04 1.109056000000e-09 -2.959288000000e-04 1.112992000000e-09 -2.150839000000e-04 1.115807000000e-09 -1.673405000000e-04 1.118621000000e-09 -1.279798000000e-04 1.121942000000e-09 -1.058274000000e-04 1.125724000000e-09 -7.572437000000e-05 1.129501000000e-09 -6.325407000000e-05 1.133249000000e-09 -4.285626000000e-05 1.135809000000e-09 -3.587991000000e-05 1.138369000000e-09 -3.454717000000e-05 1.141791000000e-09 -2.268020000000e-05 1.145734000000e-09 -1.969639000000e-05 1.150017000000e-09 -1.008213000000e-05 1.153865000000e-09 -1.102566000000e-05 1.158361000000e-09 -4.749447000000e-06 1.161824000000e-09 -6.269400000000e-06 1.165535000000e-09 -1.363381000000e-06 1.169527000000e-09 -3.004000000000e-06 1.173109000000e-09 8.421522000000e-07 1.177056000000e-09 -9.417078000000e-07 1.179535000000e-09 1.080576000000e-07 1.182013000000e-09 2.831831000000e-06 1.185429000000e-09 9.489744000000e-07 1.189651000000e-09 3.474935000000e-06 1.193349000000e-09 2.230150000000e-06 1.197208000000e-09 4.177973000000e-06 1.200595000000e-09 2.903837000000e-06 1.204042000000e-09 4.370442000000e-06 1.207661000000e-09 3.378371000000e-06 1.212044000000e-09 4.811622000000e-06 1.215603000000e-09 3.987101000000e-06 1.219624000000e-09 5.079813000000e-06 1.222280000000e-09 5.068909000000e-06 1.224935000000e-09 4.475377000000e-06 1.228316000000e-09 5.352252000000e-06 1.229186000000e-09 5.237903000000e-06 1.230042000000e-09 5.195261000000e-06 1.232779000000e-09 6.109705000000e-06 1.235670000000e-09 6.042910000000e-06 1.238863000000e-09 6.018342000000e-06 1.243639000000e-09 5.931768000000e-06 1.246999000000e-09 5.993830000000e-06 1.250850000000e-09 5.921389000000e-06 1.255187000000e-09 5.993005000000e-06 1.258822000000e-09 5.926268000000e-06 1.259631000000e-09 5.957748000000e-06 1.260438000000e-09 5.962806000000e-06 1.263021000000e-09 5.962821000000e-06 1.265957000000e-09 5.965550000000e-06 1.269137000000e-09 5.963348000000e-06 1.273131000000e-09 5.966366000000e-06 1.276658000000e-09 5.964780000000e-06 1.280195000000e-09 5.967580000000e-06 1.284359000000e-09 5.966149000000e-06 1.288216000000e-09 5.968636000000e-06 1.291735000000e-09 5.966902000000e-06 1.292574000000e-09 5.968095000000e-06 1.293423000000e-09 5.968372000000e-06 1.296139000000e-09 5.968299000000e-06 1.299136000000e-09 5.968543000000e-06 1.302736000000e-09 5.968704000000e-06 1.306959000000e-09 5.969188000000e-06 1.310392000000e-09 5.972344000000e-06 1.314112000000e-09 5.956544000000e-06 1.317424000000e-09 5.978541000000e-06 1.320972000000e-09 5.970965000000e-06 1.324632000000e-09 5.967795000000e-06 1.327145000000e-09 5.979020000000e-06 1.329658000000e-09 6.001157000000e-06 1.333049000000e-09 6.277378000000e-06 1.337028000000e-09 5.454567000000e-06 1.341293000000e-09 5.709642000000e-06 1.345153000000e-09 5.672985000000e-06 1.349994000000e-09 8.954332000000e-06 1.353616000000e-09 2.852987000000e-05 1.357116000000e-09 1.576057000000e-05 1.357983000000e-09 9.532403000000e-06 1.358962000000e-09 9.299848000000e-07 1.362092000000e-09 -3.311334000000e-05 1.364885000000e-09 -8.077587000000e-05 1.369987000000e-09 3.454912000000e-05 1.373500000000e-09 5.696383000000e-04 1.377230000000e-09 1.322629000000e-03 1.381288000000e-09 -1.121870000000e-06 1.384815000000e-09 -5.851917000000e-03 1.388662000000e-09 -1.796574000000e-02 1.389532000000e-09 -2.115314000000e-02 1.390483000000e-09 -2.420624000000e-02 1.393528000000e-09 -1.677048000000e-02 1.396267000000e-09 2.190919000000e-02 1.399530000000e-09 1.032559000000e-01 1.403009000000e-09 1.992141000000e-01 1.406745000000e-09 2.861750000000e-01 1.410579000000e-09 3.668829000000e-01 1.413057000000e-09 4.227241000000e-01 1.415535000000e-09 4.814453000000e-01 1.418933000000e-09 5.603800000000e-01 1.419781000000e-09 5.784061000000e-01 1.420563000000e-09 5.945236000000e-01 1.423064000000e-09 6.405816000000e-01 1.426220000000e-09 6.864997000000e-01 1.429627000000e-09 7.228788000000e-01 1.432942000000e-09 7.485267000000e-01 1.436511000000e-09 7.695541000000e-01 1.439973000000e-09 7.869806000000e-01 1.444113000000e-09 8.054736000000e-01 1.447667000000e-09 8.185051000000e-01 1.448597000000e-09 8.213297000000e-01 1.449278000000e-09 8.233499000000e-01 1.451458000000e-09 8.291556000000e-01 1.454984000000e-09 8.365131000000e-01 1.458241000000e-09 8.413661000000e-01 1.461761000000e-09 8.451969000000e-01 1.465886000000e-09 8.486012000000e-01 1.469389000000e-09 8.508245000000e-01 1.472794000000e-09 8.524791000000e-01 1.475276000000e-09 8.534264000000e-01 1.477758000000e-09 8.541558000000e-01 1.479095000000e-09 8.544781000000e-01 1.479882000000e-09 8.546643000000e-01 1.482402000000e-09 8.552307000000e-01 1.485321000000e-09 8.558535000000e-01 1.488790000000e-09 8.565319000000e-01 1.492381000000e-09 8.571391000000e-01 1.496661000000e-09 8.577477000000e-01 1.500576000000e-09 8.582165000000e-01 1.504103000000e-09 8.585766000000e-01 1.508121000000e-09 8.589177000000e-01 1.509046000000e-09 8.589843000000e-01 1.509764000000e-09 8.590349000000e-01 1.512062000000e-09 8.591829000000e-01 1.514727000000e-09 8.593296000000e-01 1.518391000000e-09 8.594931000000e-01 1.521668000000e-09 8.596072000000e-01 1.525243000000e-09 8.597038000000e-01 1.529365000000e-09 8.597865000000e-01 1.532875000000e-09 8.598383000000e-01 1.534025000000e-09 8.598522000000e-01 1.534117000000e-09 8.577468000000e-01 1.534180000000e-09 8.564272000000e-01 1.534382000000e-09 8.531464000000e-01 1.534737000000e-09 8.493664000000e-01 1.535025000000e-09 8.483729000000e-01 1.535086000000e-09 8.491217000000e-01 1.535120000000e-09 8.495360000000e-01 1.535227000000e-09 8.506589000000e-01 1.535516000000e-09 8.529650000000e-01 1.535770000000e-09 8.546251000000e-01 1.536253000000e-09 8.570515000000e-01 1.537797000000e-09 8.612824000000e-01 1.540037000000e-09 8.621612000000e-01 1.542991000000e-09 8.615136000000e-01 1.546340000000e-09 8.608068000000e-01 1.549563000000e-09 8.603831000000e-01 1.553023000000e-09 8.600997000000e-01 1.556674000000e-09 8.599852000000e-01 1.561332000000e-09 8.599295000000e-01 1.564959000000e-09 8.599494000000e-01 1.568637000000e-09 8.599456000000e-01 1.572862000000e-09 8.599693000000e-01 1.576410000000e-09 8.599625000000e-01 1.580380000000e-09 8.599818000000e-01 1.584817000000e-09 8.599726000000e-01 1.588226000000e-09 8.599872000000e-01 1.592181000000e-09 8.599753000000e-01 1.595925000000e-09 8.599900000000e-01 1.599741000000e-09 8.599772000000e-01 1.604581000000e-09 8.599974000000e-01 1.606342000000e-09 8.599922000000e-01 1.608103000000e-09 8.599802000000e-01 1.611836000000e-09 8.599944000000e-01 1.616035000000e-09 8.599799000000e-01 1.619218000000e-09 8.599937000000e-01 1.623182000000e-09 8.599788000000e-01 1.626358000000e-09 8.599933000000e-01 1.629985000000e-09 8.599786000000e-01 1.634074000000e-09 8.599932000000e-01 1.638238000000e-09 8.599786000000e-01 1.643068000000e-09 8.599933000000e-01 1.648476000000e-09 8.599788000000e-01 1.653917000000e-09 8.599935000000e-01 1.658595000000e-09 8.599789000000e-01 1.665047000000e-09 8.599936000000e-01 1.668427000000e-09 8.599789000000e-01 1.674362000000e-09 8.600039000000e-01 1.678501000000e-09 8.599819000000e-01 1.684581000000e-09 8.599969000000e-01 1.686093000000e-09 8.599885000000e-01 1.687486000000e-09 8.599882000000e-01 1.691945000000e-09 8.599880000000e-01 1.695547000000e-09 8.599878000000e-01 1.700342000000e-09 8.599876000000e-01 1.704014000000e-09 8.599874000000e-01 1.707642000000e-09 8.599878000000e-01 1.712914000000e-09 8.599879000000e-01 1.717024000000e-09 8.599883000000e-01 1.722796000000e-09 8.599860000000e-01 1.724262000000e-09 8.599860000000e-01 1.725743000000e-09 8.599857000000e-01 1.730482000000e-09 8.599830000000e-01 1.734128000000e-09 8.599830000000e-01 1.739613000000e-09 8.599813000000e-01 1.743241000000e-09 8.599782000000e-01 1.746998000000e-09 8.600105000000e-01 1.752400000000e-09 8.601090000000e-01 1.756586000000e-09 8.601385000000e-01 1.762468000000e-09 8.600733000000e-01 1.764025000000e-09 8.600107000000e-01 1.765380000000e-09 8.599288000000e-01 1.769719000000e-09 8.593902000000e-01 1.773264000000e-09 8.587770000000e-01 1.778028000000e-09 8.575395000000e-01 1.781718000000e-09 8.558811000000e-01 1.785310000000e-09 8.561459000000e-01 1.790811000000e-09 8.701740000000e-01 1.794844000000e-09 8.893725000000e-01 1.800637000000e-09 9.070239000000e-01 1.802097000000e-09 9.027791000000e-01 1.803580000000e-09 8.935979000000e-01 1.808326000000e-09 7.946826000000e-01 1.811970000000e-09 6.565678000000e-01 1.817496000000e-09 4.163012000000e-01 1.821120000000e-09 2.816845000000e-01 1.824884000000e-09 1.790947000000e-01 1.830308000000e-09 9.671803000000e-02 1.834495000000e-09 6.509051000000e-02 1.840377000000e-09 3.837054000000e-02 1.841939000000e-09 3.348148000000e-02 1.843284000000e-09 2.936121000000e-02 1.847586000000e-09 1.777763000000e-02 1.851115000000e-09 1.084714000000e-02 1.855851000000e-09 5.258070000000e-03 1.859543000000e-09 2.956122000000e-03 1.863125000000e-09 1.683521000000e-03 1.868621000000e-09 6.835993000000e-04 1.872640000000e-09 3.657753000000e-04 1.878406000000e-09 1.481291000000e-04 1.879857000000e-09 1.226183000000e-04 1.881342000000e-09 9.935846000000e-05 1.886097000000e-09 5.186388000000e-05 1.889729000000e-09 3.419447000000e-05 1.895406000000e-09 1.963713000000e-05 1.899019000000e-09 1.460156000000e-05 1.902802000000e-09 1.120933000000e-05 1.908327000000e-09 8.788323000000e-06 1.912510000000e-09 7.619461000000e-06 1.918396000000e-09 6.925837000000e-06 1.923452000000e-09 6.602718000000e-06 1.928319000000e-09 6.442008000000e-06 1.933832000000e-09 6.325949000000e-06 1.937865000000e-09 6.274944000000e-06 1.941516000000e-09 6.255975000000e-06 1.947123000000e-09 6.241259000000e-06 1.951206000000e-09 6.238523000000e-06 1.957151000000e-09 6.229333000000e-06 1.962202000000e-09 6.226344000000e-06 1.967100000000e-09 6.223652000000e-06 1.968013000000e-09 6.224103000000e-06 1.969099000000e-09 6.223885000000e-06 1.972453000000e-09 6.223090000000e-06 1.975701000000e-09 6.222755000000e-06 1.979195000000e-09 6.222648000000e-06 1.983866000000e-09 6.222235000000e-06 1.987814000000e-09 6.222040000000e-06 1.993099000000e-09 6.221826000000e-06 1.998488000000e-09 6.221793000000e-06 2.003935000000e-09 6.221760000000e-06 2.004866000000e-09 6.221756000000e-06 2.005730000000e-09 6.221750000000e-06 2.008495000000e-09 6.221735000000e-06 2.013208000000e-09 6.221717000000e-06 2.016501000000e-09 6.221725000000e-06 2.021215000000e-09 6.221715000000e-06 2.025252000000e-09 6.221713000000e-06 2.030301000000e-09 6.221710000000e-06 2.035760000000e-09 6.221712000000e-06 2.040977000000e-09 6.221709000000e-06 2.042009000000e-09 6.221710000000e-06 2.042812000000e-09 6.221710000000e-06 2.045379000000e-09 6.221709000000e-06 2.049639000000e-09 6.221710000000e-06 2.053254000000e-09 6.221709000000e-06 2.056728000000e-09 6.221709000000e-06 2.062152000000e-09 6.221709000000e-06 2.066039000000e-09 6.221709000000e-06 2.071558000000e-09 6.221709000000e-06 2.076872000000e-09 6.221709000000e-06 2.078300000000e-09 6.221709000000e-06 2.079144000000e-09 6.221709000000e-06 2.081843000000e-09 6.221709000000e-06 2.085459000000e-09 6.221709000000e-06 2.089564000000e-09 6.221709000000e-06 2.093109000000e-09 6.221710000000e-06 2.096789000000e-09 6.221710000000e-06 2.101106000000e-09 6.221710000000e-06 2.105378000000e-09 6.221710000000e-06 2.110838000000e-09 6.221710000000e-06 2.112251000000e-09 6.221710000000e-06 2.113753000000e-09 6.221710000000e-06 2.118558000000e-09 6.221710000000e-06 2.122133000000e-09 6.221710000000e-06 2.129360000000e-09 6.221710000000e-06 2.132821000000e-09 6.221710000000e-06 2.136929000000e-09 6.221710000000e-06 2.139763000000e-09 6.221710000000e-06 2.142597000000e-09 6.221710000000e-06 2.147012000000e-09 6.221710000000e-06 2.152765000000e-09 6.221710000000e-06 2.154377000000e-09 6.221710000000e-06 2.155442000000e-09 6.221710000000e-06 2.158852000000e-09 6.221710000000e-06 2.162621000000e-09 6.221710000000e-06 2.166944000000e-09 6.221710000000e-06 2.170618000000e-09 6.221710000000e-06 2.174167000000e-09 6.221710000000e-06 2.179170000000e-09 6.221710000000e-06 2.183292000000e-09 6.221783000000e-06 2.188867000000e-09 6.221663000000e-06 2.190278000000e-09 6.221673000000e-06 2.191779000000e-09 6.221687000000e-06 2.196584000000e-09 6.221702000000e-06 2.200169000000e-09 6.221705000000e-06 2.207050000000e-09 6.221709000000e-06 2.210543000000e-09 6.221709000000e-06 2.214570000000e-09 6.221710000000e-06 2.217383000000e-09 6.221710000000e-06 2.220196000000e-09 6.221710000000e-06 2.224548000000e-09 6.221710000000e-06 2.230327000000e-09 6.221710000000e-06 2.231668000000e-09 6.221710000000e-06 2.232487000000e-09 6.221710000000e-06 2.235108000000e-09 6.221710000000e-06 2.238430000000e-09 6.221710000000e-06 2.242101000000e-09 6.221710000000e-06 2.245250000000e-09 6.221710000000e-06 2.248623000000e-09 6.221710000000e-06 2.252399000000e-09 6.221710000000e-06 2.256336000000e-09 6.221710000000e-06 2.261919000000e-09 6.221710000000e-06 2.264384000000e-09 6.221710000000e-06 2.265883000000e-09 6.221710000000e-06 2.270679000000e-09 6.221710000000e-06 2.277378000000e-09 6.221710000000e-06 2.283984000000e-09 6.221710000000e-06 2.291963000000e-09 6.221710000000e-06 2.303337000000e-09 6.221710000000e-06 2.323042000000e-09 6.221710000000e-06 2.352076000000e-09 6.221710000000e-06 2.407975000000e-09 6.221710000000e-06 2.543499000000e-09 6.221710000000e-06 2.778736000000e-09 6.221711000000e-06 3.128736000000e-09 6.221711000000e-06 3.478736000000e-09 6.221711000000e-06 3.828736000000e-09 6.221711000000e-06 4.076000000000e-09 6.221711000000e-06 4.076500000000e-09 2.037624000000e-02 4.077000000000e-09 4.006723000000e-02 4.077306000000e-09 3.904547000000e-02 4.077515000000e-09 3.824809000000e-02 4.078112000000e-09 3.570875000000e-02 4.079900000000e-09 2.849821000000e-02 4.082540000000e-09 1.954990000000e-02 4.086501000000e-09 1.040376000000e-02 4.092049000000e-09 3.783148000000e-03 4.100074000000e-09 6.728290000000e-04 4.112222000000e-09 -3.187700000000e-05 4.128358000000e-09 2.202224000000e-05 4.151784000000e-09 -4.243351000000e-06 4.181738000000e-09 1.638222000000e-05 4.223091000000e-09 -1.068745000000e-06 4.287381000000e-09 1.500047000000e-05 4.412795000000e-09 -6.963529000000e-07 4.639879000000e-09 1.497477000000e-05 4.989879000000e-09 -1.114760000000e-06 5.339879000000e-09 1.533521000000e-05 5.689879000000e-09 -1.415591000000e-06 6.039879000000e-09 1.562735000000e-05 6.389879000000e-09 -1.716676000000e-06 6.739879000000e-09 1.588207000000e-05 7.000000000000e-09 -2.006349000000e-06)
V_XOR_19 xor_19 0 PWL(0.000000000000e+00 6.995221000000e-06 1.000000000000e-12 6.997984000000e-06 2.000000000000e-12 7.000502000000e-06 5.200000000000e-12 7.006871000000e-06 1.544000000000e-11 7.014253000000e-06 4.820800000000e-11 7.014547000000e-06 1.530656000000e-10 7.014629000000e-06 4.886099000000e-10 7.014537000000e-06 8.386099000000e-10 7.014631000000e-06 9.995000000000e-10 7.014537000000e-06 9.996500000000e-10 7.014541000000e-06 1.000130000000e-09 7.014550000000e-06 1.000271000000e-09 7.014553000000e-06 1.000500000000e-09 7.014556000000e-06 1.000549000000e-09 7.014557000000e-06 1.000579000000e-09 7.014557000000e-06 1.000674000000e-09 7.014559000000e-06 1.000921000000e-09 7.014561000000e-06 1.001177000000e-09 7.014564000000e-06 1.001636000000e-09 7.014567000000e-06 1.002995000000e-09 7.014574000000e-06 1.004717000000e-09 7.014578000000e-06 1.007157000000e-09 7.014583000000e-06 1.009530000000e-09 7.014585000000e-06 1.012064000000e-09 7.014586000000e-06 1.014479000000e-09 7.014587000000e-06 1.016999000000e-09 7.014587000000e-06 1.019780000000e-09 7.014587000000e-06 1.023006000000e-09 7.014586000000e-06 1.025715000000e-09 7.014586000000e-06 1.028767000000e-09 7.014585000000e-06 1.031545000000e-09 7.014585000000e-06 1.034548000000e-09 7.014585000000e-06 1.037295000000e-09 7.014585000000e-06 1.040188000000e-09 7.014584000000e-06 1.042931000000e-09 7.014584000000e-06 1.046095000000e-09 7.014584000000e-06 1.049020000000e-09 7.014584000000e-06 1.051920000000e-09 7.014584000000e-06 1.055268000000e-09 7.014584000000e-06 1.057963000000e-09 7.014584000000e-06 1.059420000000e-09 7.014584000000e-06 1.060877000000e-09 7.014584000000e-06 1.063981000000e-09 7.014584000000e-06 1.066813000000e-09 7.014584000000e-06 1.069715000000e-09 7.014584000000e-06 1.073141000000e-09 7.014584000000e-06 1.075000000000e-09 7.014584000000e-06 1.075500000000e-09 -2.045888000000e-02 1.075834000000e-09 -3.391895000000e-02 1.076000000000e-09 -4.043047000000e-02 1.076266000000e-09 -3.910846000000e-02 1.076419000000e-09 -3.826786000000e-02 1.076822000000e-09 -3.580911000000e-02 1.078112000000e-09 -2.860478000000e-02 1.079915000000e-09 -2.077672000000e-02 1.082834000000e-09 -1.253812000000e-02 1.086452000000e-09 -6.732492000000e-03 1.089863000000e-09 -3.811583000000e-03 1.094093000000e-09 -1.921681000000e-03 1.097558000000e-09 -1.165445000000e-03 1.101264000000e-09 -7.065969000000e-04 1.105520000000e-09 -4.344228000000e-04 1.109056000000e-09 -2.959288000000e-04 1.112992000000e-09 -2.150839000000e-04 1.115807000000e-09 -1.673405000000e-04 1.118621000000e-09 -1.279798000000e-04 1.121942000000e-09 -1.058274000000e-04 1.125724000000e-09 -7.572437000000e-05 1.129501000000e-09 -6.325407000000e-05 1.133249000000e-09 -4.285626000000e-05 1.135809000000e-09 -3.587991000000e-05 1.138369000000e-09 -3.454717000000e-05 1.141791000000e-09 -2.268020000000e-05 1.145734000000e-09 -1.969639000000e-05 1.150017000000e-09 -1.008213000000e-05 1.153865000000e-09 -1.102566000000e-05 1.158361000000e-09 -4.749447000000e-06 1.161824000000e-09 -6.269400000000e-06 1.165535000000e-09 -1.363381000000e-06 1.169527000000e-09 -3.004000000000e-06 1.173109000000e-09 8.421522000000e-07 1.177056000000e-09 -9.417078000000e-07 1.179535000000e-09 1.080576000000e-07 1.182013000000e-09 2.831831000000e-06 1.185429000000e-09 9.489744000000e-07 1.189651000000e-09 3.474935000000e-06 1.193349000000e-09 2.230150000000e-06 1.197208000000e-09 4.177973000000e-06 1.200595000000e-09 2.903837000000e-06 1.204042000000e-09 4.370442000000e-06 1.207661000000e-09 3.378371000000e-06 1.212044000000e-09 4.811622000000e-06 1.215603000000e-09 3.987101000000e-06 1.219624000000e-09 5.079813000000e-06 1.222280000000e-09 5.068909000000e-06 1.224935000000e-09 4.475377000000e-06 1.228316000000e-09 5.352252000000e-06 1.229186000000e-09 5.237903000000e-06 1.230042000000e-09 5.195261000000e-06 1.232779000000e-09 6.109705000000e-06 1.235670000000e-09 6.042910000000e-06 1.238863000000e-09 6.018342000000e-06 1.243639000000e-09 5.931768000000e-06 1.246999000000e-09 5.993830000000e-06 1.250850000000e-09 5.921389000000e-06 1.255187000000e-09 5.993005000000e-06 1.258822000000e-09 5.926268000000e-06 1.259631000000e-09 5.957748000000e-06 1.260438000000e-09 5.962806000000e-06 1.263021000000e-09 5.962821000000e-06 1.265957000000e-09 5.965550000000e-06 1.269137000000e-09 5.963352000000e-06 1.273131000000e-09 5.966357000000e-06 1.276658000000e-09 5.964792000000e-06 1.280195000000e-09 5.967573000000e-06 1.284359000000e-09 5.966149000000e-06 1.288216000000e-09 5.968612000000e-06 1.291735000000e-09 5.967078000000e-06 1.292574000000e-09 5.968039000000e-06 1.293423000000e-09 5.968190000000e-06 1.296139000000e-09 5.968323000000e-06 1.299136000000e-09 5.968588000000e-06 1.302736000000e-09 5.968720000000e-06 1.306959000000e-09 5.968960000000e-06 1.310392000000e-09 5.969049000000e-06 1.314112000000e-09 5.968978000000e-06 1.317424000000e-09 5.969545000000e-06 1.320972000000e-09 5.969089000000e-06 1.324632000000e-09 5.969301000000e-06 1.327145000000e-09 5.969483000000e-06 1.329658000000e-09 5.969693000000e-06 1.333049000000e-09 5.972199000000e-06 1.337028000000e-09 5.957473000000e-06 1.341293000000e-09 5.980852000000e-06 1.345153000000e-09 5.968087000000e-06 1.349994000000e-09 5.994013000000e-06 1.353616000000e-09 6.271701000000e-06 1.357116000000e-09 5.524414000000e-06 1.357983000000e-09 5.578885000000e-06 1.358962000000e-09 5.608981000000e-06 1.362092000000e-09 5.698680000000e-06 1.364885000000e-09 5.661096000000e-06 1.369987000000e-09 7.364397000000e-06 1.373500000000e-09 1.158076000000e-05 1.377230000000e-09 2.644406000000e-05 1.381288000000e-09 -6.611765000000e-06 1.384815000000e-09 -5.095673000000e-05 1.388662000000e-09 -1.052024000000e-04 1.389532000000e-09 -9.267498000000e-05 1.390483000000e-09 -5.876097000000e-05 1.393528000000e-09 3.798952000000e-04 1.396267000000e-09 9.955133000000e-04 1.399530000000e-09 1.418780000000e-03 1.403009000000e-09 -3.924194000000e-04 1.406745000000e-09 -7.553450000000e-03 1.410579000000e-09 -2.006291000000e-02 1.413057000000e-09 -1.618706000000e-02 1.415535000000e-09 -2.917408000000e-03 1.418933000000e-09 5.724319000000e-02 1.419781000000e-09 7.995978000000e-02 1.420563000000e-09 1.013181000000e-01 1.423064000000e-09 1.704790000000e-01 1.426220000000e-09 2.489942000000e-01 1.429627000000e-09 3.213857000000e-01 1.432942000000e-09 3.928652000000e-01 1.436511000000e-09 4.766328000000e-01 1.439973000000e-09 5.568195000000e-01 1.444113000000e-09 6.380172000000e-01 1.447667000000e-09 6.895974000000e-01 1.448597000000e-09 7.000643000000e-01 1.449278000000e-09 7.074452000000e-01 1.451458000000e-09 7.280601000000e-01 1.454984000000e-09 7.537336000000e-01 1.458241000000e-09 7.721457000000e-01 1.461761000000e-09 7.896381000000e-01 1.465886000000e-09 8.076674000000e-01 1.469389000000e-09 8.200880000000e-01 1.472794000000e-09 8.295342000000e-01 1.475276000000e-09 8.349669000000e-01 1.477758000000e-09 8.391748000000e-01 1.479095000000e-09 8.409262000000e-01 1.479882000000e-09 8.419160000000e-01 1.482402000000e-09 8.446612000000e-01 1.485321000000e-09 8.472487000000e-01 1.488790000000e-09 8.497324000000e-01 1.492381000000e-09 8.517274000000e-01 1.496661000000e-09 8.534491000000e-01 1.500576000000e-09 8.545352000000e-01 1.504103000000e-09 8.553254000000e-01 1.508121000000e-09 8.561659000000e-01 1.509046000000e-09 8.563440000000e-01 1.509764000000e-09 8.564801000000e-01 1.512062000000e-09 8.568876000000e-01 1.514727000000e-09 8.573094000000e-01 1.518391000000e-09 8.578144000000e-01 1.521668000000e-09 8.582045000000e-01 1.525243000000e-09 8.585711000000e-01 1.529365000000e-09 8.589209000000e-01 1.532875000000e-09 8.591612000000e-01 1.534025000000e-09 8.592291000000e-01 1.534117000000e-09 8.571901000000e-01 1.534180000000e-09 8.558260000000e-01 1.534382000000e-09 8.525831000000e-01 1.534737000000e-09 8.487645000000e-01 1.535025000000e-09 8.477911000000e-01 1.535086000000e-09 8.485262000000e-01 1.535120000000e-09 8.489387000000e-01 1.535227000000e-09 8.500619000000e-01 1.535516000000e-09 8.523683000000e-01 1.535770000000e-09 8.540328000000e-01 1.536253000000e-09 8.564703000000e-01 1.537797000000e-09 8.607297000000e-01 1.540037000000e-09 8.617062000000e-01 1.542991000000e-09 8.611753000000e-01 1.546340000000e-09 8.605622000000e-01 1.549563000000e-09 8.602075000000e-01 1.553023000000e-09 8.599780000000e-01 1.556674000000e-09 8.599017000000e-01 1.561332000000e-09 8.598747000000e-01 1.564959000000e-09 8.599121000000e-01 1.568637000000e-09 8.599175000000e-01 1.572862000000e-09 8.599523000000e-01 1.576410000000e-09 8.599473000000e-01 1.580380000000e-09 8.599721000000e-01 1.584817000000e-09 8.599637000000e-01 1.588226000000e-09 8.599829000000e-01 1.592181000000e-09 8.599705000000e-01 1.595925000000e-09 8.599882000000e-01 1.599741000000e-09 8.599741000000e-01 1.604581000000e-09 8.599913000000e-01 1.606342000000e-09 8.599867000000e-01 1.608103000000e-09 8.599763000000e-01 1.611836000000e-09 8.599923000000e-01 1.616035000000e-09 8.599770000000e-01 1.619218000000e-09 8.599930000000e-01 1.623182000000e-09 8.599773000000e-01 1.626358000000e-09 8.599933000000e-01 1.629985000000e-09 8.599775000000e-01 1.634074000000e-09 8.599935000000e-01 1.638238000000e-09 8.599778000000e-01 1.643068000000e-09 8.599938000000e-01 1.648476000000e-09 8.599781000000e-01 1.653917000000e-09 8.599941000000e-01 1.658595000000e-09 8.599783000000e-01 1.665047000000e-09 8.599942000000e-01 1.668427000000e-09 8.599784000000e-01 1.674362000000e-09 8.599940000000e-01 1.678501000000e-09 8.599784000000e-01 1.684581000000e-09 8.599941000000e-01 1.686093000000e-09 8.599866000000e-01 1.687486000000e-09 8.599864000000e-01 1.691945000000e-09 8.599870000000e-01 1.695547000000e-09 8.599870000000e-01 1.700342000000e-09 8.599872000000e-01 1.704014000000e-09 8.599871000000e-01 1.707642000000e-09 8.599873000000e-01 1.712914000000e-09 8.599872000000e-01 1.717024000000e-09 8.599873000000e-01 1.722796000000e-09 8.599872000000e-01 1.724262000000e-09 8.599873000000e-01 1.725743000000e-09 8.599873000000e-01 1.730482000000e-09 8.599873000000e-01 1.734128000000e-09 8.599873000000e-01 1.739613000000e-09 8.599873000000e-01 1.743241000000e-09 8.599873000000e-01 1.746998000000e-09 8.599877000000e-01 1.752400000000e-09 8.599878000000e-01 1.756586000000e-09 8.599878000000e-01 1.762468000000e-09 8.599861000000e-01 1.764025000000e-09 8.599860000000e-01 1.765380000000e-09 8.599854000000e-01 1.769719000000e-09 8.599829000000e-01 1.773264000000e-09 8.599831000000e-01 1.778028000000e-09 8.599819000000e-01 1.781718000000e-09 8.599755000000e-01 1.785310000000e-09 8.600032000000e-01 1.790811000000e-09 8.601206000000e-01 1.794844000000e-09 8.601436000000e-01 1.800637000000e-09 8.601027000000e-01 1.802097000000e-09 8.600582000000e-01 1.803580000000e-09 8.599845000000e-01 1.808326000000e-09 8.594370000000e-01 1.811970000000e-09 8.588138000000e-01 1.817496000000e-09 8.573001000000e-01 1.821120000000e-09 8.556751000000e-01 1.824884000000e-09 8.568498000000e-01 1.830308000000e-09 8.725749000000e-01 1.834495000000e-09 8.928136000000e-01 1.840377000000e-09 9.049251000000e-01 1.841939000000e-09 8.954186000000e-01 1.843284000000e-09 8.826495000000e-01 1.847586000000e-09 7.825692000000e-01 1.851115000000e-09 6.465165000000e-01 1.855851000000e-09 4.384061000000e-01 1.859543000000e-09 2.976147000000e-01 1.863125000000e-09 1.944616000000e-01 1.868621000000e-09 1.029458000000e-01 1.872640000000e-09 6.994836000000e-02 1.878406000000e-09 4.156103000000e-02 1.879857000000e-09 3.682642000000e-02 1.881342000000e-09 3.210025000000e-02 1.886097000000e-09 1.875337000000e-02 1.889729000000e-09 1.129644000000e-02 1.895406000000e-09 4.658291000000e-03 1.899019000000e-09 2.641205000000e-03 1.902802000000e-09 1.451504000000e-03 1.908327000000e-09 5.872053000000e-04 1.912510000000e-09 3.062823000000e-04 1.918396000000e-09 1.227932000000e-04 1.923452000000e-09 5.841788000000e-05 1.928319000000e-09 3.277584000000e-05 1.933832000000e-09 1.876614000000e-05 1.937865000000e-09 1.484277000000e-05 1.941516000000e-09 1.055336000000e-05 1.947123000000e-09 9.228862000000e-06 1.951206000000e-09 7.258348000000e-06 1.957151000000e-09 7.659750000000e-06 1.962202000000e-09 6.231119000000e-06 1.967100000000e-09 7.118704000000e-06 1.968013000000e-09 6.549635000000e-06 1.969099000000e-09 6.548354000000e-06 1.972453000000e-09 6.360281000000e-06 1.975701000000e-09 6.323789000000e-06 1.979195000000e-09 6.317313000000e-06 1.983866000000e-09 6.294665000000e-06 1.987814000000e-09 6.298466000000e-06 1.993099000000e-09 6.279809000000e-06 1.998488000000e-09 6.283203000000e-06 2.003935000000e-09 6.272685000000e-06 2.004866000000e-09 6.275736000000e-06 2.005730000000e-09 6.275787000000e-06 2.008495000000e-09 6.274777000000e-06 2.013208000000e-09 6.273338000000e-06 2.016501000000e-09 6.273141000000e-06 2.021215000000e-09 6.272980000000e-06 2.025252000000e-09 6.272634000000e-06 2.030301000000e-09 6.272455000000e-06 2.035760000000e-09 6.272342000000e-06 2.040977000000e-09 6.272347000000e-06 2.042009000000e-09 6.272323000000e-06 2.042812000000e-09 6.272310000000e-06 2.045379000000e-09 6.272300000000e-06 2.049639000000e-09 6.272284000000e-06 2.053254000000e-09 6.272286000000e-06 2.056728000000e-09 6.272274000000e-06 2.062152000000e-09 6.272273000000e-06 2.066039000000e-09 6.272267000000e-06 2.071558000000e-09 6.272269000000e-06 2.076872000000e-09 6.272267000000e-06 2.078300000000e-09 6.272267000000e-06 2.079144000000e-09 6.272267000000e-06 2.081843000000e-09 6.272267000000e-06 2.085459000000e-09 6.272267000000e-06 2.089564000000e-09 6.272266000000e-06 2.093109000000e-09 6.272266000000e-06 2.096789000000e-09 6.272266000000e-06 2.101106000000e-09 6.272266000000e-06 2.105378000000e-09 6.272266000000e-06 2.110838000000e-09 6.272266000000e-06 2.112251000000e-09 6.272266000000e-06 2.113753000000e-09 6.272266000000e-06 2.118558000000e-09 6.272266000000e-06 2.122133000000e-09 6.272266000000e-06 2.129360000000e-09 6.272266000000e-06 2.132821000000e-09 6.272266000000e-06 2.136929000000e-09 6.272266000000e-06 2.139763000000e-09 6.272266000000e-06 2.142597000000e-09 6.272266000000e-06 2.147012000000e-09 6.272266000000e-06 2.152765000000e-09 6.272267000000e-06 2.154377000000e-09 6.272266000000e-06 2.155442000000e-09 6.272266000000e-06 2.158852000000e-09 6.272267000000e-06 2.162621000000e-09 6.272267000000e-06 2.166944000000e-09 6.272267000000e-06 2.170618000000e-09 6.272267000000e-06 2.174167000000e-09 6.272267000000e-06 2.179170000000e-09 6.272267000000e-06 2.183292000000e-09 6.272267000000e-06 2.188867000000e-09 6.272267000000e-06 2.190278000000e-09 6.272267000000e-06 2.191779000000e-09 6.272267000000e-06 2.196584000000e-09 6.272267000000e-06 2.200169000000e-09 6.272267000000e-06 2.207050000000e-09 6.272267000000e-06 2.210543000000e-09 6.272267000000e-06 2.214570000000e-09 6.272267000000e-06 2.217383000000e-09 6.272267000000e-06 2.220196000000e-09 6.272267000000e-06 2.224548000000e-09 6.272267000000e-06 2.230327000000e-09 6.272267000000e-06 2.231668000000e-09 6.272267000000e-06 2.232487000000e-09 6.272267000000e-06 2.235108000000e-09 6.272267000000e-06 2.238430000000e-09 6.272267000000e-06 2.242101000000e-09 6.272267000000e-06 2.245250000000e-09 6.272267000000e-06 2.248623000000e-09 6.272267000000e-06 2.252399000000e-09 6.272267000000e-06 2.256336000000e-09 6.272267000000e-06 2.261919000000e-09 6.272267000000e-06 2.264384000000e-09 6.272267000000e-06 2.265883000000e-09 6.272267000000e-06 2.270679000000e-09 6.272267000000e-06 2.277378000000e-09 6.272267000000e-06 2.283984000000e-09 6.272267000000e-06 2.291963000000e-09 6.272267000000e-06 2.303337000000e-09 6.272267000000e-06 2.323042000000e-09 6.272267000000e-06 2.352076000000e-09 6.272267000000e-06 2.407975000000e-09 6.272267000000e-06 2.543499000000e-09 6.272268000000e-06 2.778736000000e-09 6.272264000000e-06 3.128736000000e-09 6.272271000000e-06 3.478736000000e-09 6.272263000000e-06 3.828736000000e-09 6.272272000000e-06 4.076000000000e-09 6.272261000000e-06 4.076500000000e-09 2.037710000000e-02 4.077000000000e-09 4.006817000000e-02 4.077306000000e-09 3.904640000000e-02 4.077515000000e-09 3.824902000000e-02 4.078112000000e-09 3.570961000000e-02 4.079900000000e-09 2.849880000000e-02 4.082540000000e-09 1.955018000000e-02 4.086501000000e-09 1.040387000000e-02 4.092049000000e-09 3.783177000000e-03 4.100074000000e-09 6.728316000000e-04 4.112222000000e-09 -3.187684000000e-05 4.128358000000e-09 2.202199000000e-05 4.151784000000e-09 -4.243048000000e-06 4.181738000000e-09 1.638201000000e-05 4.223091000000e-09 -1.068431000000e-06 4.287381000000e-09 1.500030000000e-05 4.412795000000e-09 -6.960390000000e-07 4.639879000000e-09 1.497461000000e-05 4.989879000000e-09 -1.114448000000e-06 5.339879000000e-09 1.533506000000e-05 5.689879000000e-09 -1.415285000000e-06 6.039879000000e-09 1.562720000000e-05 6.389879000000e-09 -1.716374000000e-06 6.739879000000e-09 1.588193000000e-05 7.000000000000e-09 -2.006051000000e-06)
V_XOR_20 xor_20 0 PWL(0.000000000000e+00 6.995221000000e-06 1.000000000000e-12 6.997984000000e-06 2.000000000000e-12 7.000502000000e-06 5.200000000000e-12 7.006871000000e-06 1.544000000000e-11 7.014253000000e-06 4.820800000000e-11 7.014547000000e-06 1.530656000000e-10 7.014629000000e-06 4.886099000000e-10 7.014537000000e-06 8.386099000000e-10 7.014631000000e-06 9.995000000000e-10 7.014537000000e-06 9.996500000000e-10 7.014541000000e-06 1.000130000000e-09 7.014550000000e-06 1.000271000000e-09 7.014553000000e-06 1.000500000000e-09 7.014556000000e-06 1.000549000000e-09 7.014557000000e-06 1.000579000000e-09 7.014557000000e-06 1.000674000000e-09 7.014559000000e-06 1.000921000000e-09 7.014561000000e-06 1.001177000000e-09 7.014564000000e-06 1.001636000000e-09 7.014567000000e-06 1.002995000000e-09 7.014574000000e-06 1.004717000000e-09 7.014578000000e-06 1.007157000000e-09 7.014583000000e-06 1.009530000000e-09 7.014585000000e-06 1.012064000000e-09 7.014586000000e-06 1.014479000000e-09 7.014587000000e-06 1.016999000000e-09 7.014587000000e-06 1.019780000000e-09 7.014587000000e-06 1.023006000000e-09 7.014586000000e-06 1.025715000000e-09 7.014586000000e-06 1.028767000000e-09 7.014585000000e-06 1.031545000000e-09 7.014585000000e-06 1.034548000000e-09 7.014585000000e-06 1.037295000000e-09 7.014585000000e-06 1.040188000000e-09 7.014584000000e-06 1.042931000000e-09 7.014584000000e-06 1.046095000000e-09 7.014584000000e-06 1.049020000000e-09 7.014584000000e-06 1.051920000000e-09 7.014584000000e-06 1.055268000000e-09 7.014584000000e-06 1.057963000000e-09 7.014584000000e-06 1.059420000000e-09 7.014584000000e-06 1.060877000000e-09 7.014584000000e-06 1.063981000000e-09 7.014584000000e-06 1.066813000000e-09 7.014584000000e-06 1.069715000000e-09 7.014584000000e-06 1.073141000000e-09 7.014584000000e-06 1.075000000000e-09 7.014584000000e-06 1.075500000000e-09 -2.045888000000e-02 1.075834000000e-09 -3.391895000000e-02 1.076000000000e-09 -4.043047000000e-02 1.076266000000e-09 -3.910846000000e-02 1.076419000000e-09 -3.826786000000e-02 1.076822000000e-09 -3.580911000000e-02 1.078112000000e-09 -2.860478000000e-02 1.079915000000e-09 -2.077672000000e-02 1.082834000000e-09 -1.253812000000e-02 1.086452000000e-09 -6.732492000000e-03 1.089863000000e-09 -3.811583000000e-03 1.094093000000e-09 -1.921681000000e-03 1.097558000000e-09 -1.165445000000e-03 1.101264000000e-09 -7.065969000000e-04 1.105520000000e-09 -4.344228000000e-04 1.109056000000e-09 -2.959288000000e-04 1.112992000000e-09 -2.150839000000e-04 1.115807000000e-09 -1.673405000000e-04 1.118621000000e-09 -1.279798000000e-04 1.121942000000e-09 -1.058274000000e-04 1.125724000000e-09 -7.572437000000e-05 1.129501000000e-09 -6.325407000000e-05 1.133249000000e-09 -4.285626000000e-05 1.135809000000e-09 -3.587991000000e-05 1.138369000000e-09 -3.454717000000e-05 1.141791000000e-09 -2.268020000000e-05 1.145734000000e-09 -1.969639000000e-05 1.150017000000e-09 -1.008213000000e-05 1.153865000000e-09 -1.102566000000e-05 1.158361000000e-09 -4.749447000000e-06 1.161824000000e-09 -6.269400000000e-06 1.165535000000e-09 -1.363381000000e-06 1.169527000000e-09 -3.004000000000e-06 1.173109000000e-09 8.421522000000e-07 1.177056000000e-09 -9.417078000000e-07 1.179535000000e-09 1.080576000000e-07 1.182013000000e-09 2.831831000000e-06 1.185429000000e-09 9.489744000000e-07 1.189651000000e-09 3.474935000000e-06 1.193349000000e-09 2.230150000000e-06 1.197208000000e-09 4.177973000000e-06 1.200595000000e-09 2.903837000000e-06 1.204042000000e-09 4.370442000000e-06 1.207661000000e-09 3.378371000000e-06 1.212044000000e-09 4.811622000000e-06 1.215603000000e-09 3.987101000000e-06 1.219624000000e-09 5.079813000000e-06 1.222280000000e-09 5.068909000000e-06 1.224935000000e-09 4.475377000000e-06 1.228316000000e-09 5.352252000000e-06 1.229186000000e-09 5.237903000000e-06 1.230042000000e-09 5.195261000000e-06 1.232779000000e-09 6.109705000000e-06 1.235670000000e-09 6.042910000000e-06 1.238863000000e-09 6.018342000000e-06 1.243639000000e-09 5.931768000000e-06 1.246999000000e-09 5.993830000000e-06 1.250850000000e-09 5.921389000000e-06 1.255187000000e-09 5.993005000000e-06 1.258822000000e-09 5.926268000000e-06 1.259631000000e-09 5.957748000000e-06 1.260438000000e-09 5.962806000000e-06 1.263021000000e-09 5.962821000000e-06 1.265957000000e-09 5.965550000000e-06 1.269137000000e-09 5.963352000000e-06 1.273131000000e-09 5.966357000000e-06 1.276658000000e-09 5.964792000000e-06 1.280195000000e-09 5.967573000000e-06 1.284359000000e-09 5.966149000000e-06 1.288216000000e-09 5.968612000000e-06 1.291735000000e-09 5.967080000000e-06 1.292574000000e-09 5.968035000000e-06 1.293423000000e-09 5.968186000000e-06 1.296139000000e-09 5.968327000000e-06 1.299136000000e-09 5.968588000000e-06 1.302736000000e-09 5.968719000000e-06 1.306959000000e-09 5.968958000000e-06 1.310392000000e-09 5.969016000000e-06 1.314112000000e-09 5.969168000000e-06 1.317424000000e-09 5.969198000000e-06 1.320972000000e-09 5.969293000000e-06 1.324632000000e-09 5.969312000000e-06 1.327145000000e-09 5.969350000000e-06 1.329658000000e-09 5.969408000000e-06 1.333049000000e-09 5.969418000000e-06 1.337028000000e-09 5.969292000000e-06 1.341293000000e-09 5.969775000000e-06 1.345153000000e-09 5.969213000000e-06 1.349994000000e-09 5.969781000000e-06 1.353616000000e-09 5.972229000000e-06 1.357116000000e-09 5.957318000000e-06 1.357983000000e-09 5.966053000000e-06 1.358962000000e-09 5.972288000000e-06 1.362092000000e-09 5.973132000000e-06 1.364885000000e-09 5.969630000000e-06 1.369987000000e-09 5.981703000000e-06 1.373500000000e-09 6.302539000000e-06 1.377230000000e-09 5.558899000000e-06 1.381288000000e-09 5.705202000000e-06 1.384815000000e-09 5.806229000000e-06 1.388662000000e-09 5.779140000000e-06 1.389532000000e-09 6.227717000000e-06 1.390483000000e-09 7.134970000000e-06 1.393528000000e-09 1.132870000000e-05 1.396267000000e-09 2.878948000000e-05 1.399530000000e-09 1.318823000000e-05 1.403009000000e-09 -1.697042000000e-05 1.406745000000e-09 -6.030298000000e-05 1.410579000000e-09 -9.569082000000e-05 1.413057000000e-09 9.839677000000e-05 1.415535000000e-09 4.628588000000e-04 1.418933000000e-09 1.190696000000e-03 1.419781000000e-09 1.310455000000e-03 1.420563000000e-09 1.394625000000e-03 1.423064000000e-09 7.985678000000e-04 1.426220000000e-09 -3.315587000000e-03 1.429627000000e-09 -1.238075000000e-02 1.432942000000e-09 -2.261099000000e-02 1.436511000000e-09 -1.110779000000e-02 1.439973000000e-09 4.732443000000e-02 1.444113000000e-09 1.581835000000e-01 1.447667000000e-09 2.491420000000e-01 1.448597000000e-09 2.688225000000e-01 1.449278000000e-09 2.830832000000e-01 1.451458000000e-09 3.284322000000e-01 1.454984000000e-09 4.065453000000e-01 1.458241000000e-09 4.835898000000e-01 1.461761000000e-09 5.644201000000e-01 1.465886000000e-09 6.436031000000e-01 1.469389000000e-09 6.930007000000e-01 1.472794000000e-09 7.275413000000e-01 1.475276000000e-09 7.471647000000e-01 1.477758000000e-09 7.621060000000e-01 1.479095000000e-09 7.690607000000e-01 1.479882000000e-09 7.731370000000e-01 1.482402000000e-09 7.857366000000e-01 1.485321000000e-09 7.992824000000e-01 1.488790000000e-09 8.131348000000e-01 1.492381000000e-09 8.246330000000e-01 1.496661000000e-09 8.347811000000e-01 1.500576000000e-09 8.410367000000e-01 1.504103000000e-09 8.449493000000e-01 1.508121000000e-09 8.483256000000e-01 1.509046000000e-09 8.489631000000e-01 1.509764000000e-09 8.494452000000e-01 1.512062000000e-09 8.508301000000e-01 1.514727000000e-09 8.521567000000e-01 1.518391000000e-09 8.535441000000e-01 1.521668000000e-09 8.544454000000e-01 1.525243000000e-09 8.552570000000e-01 1.529365000000e-09 8.561223000000e-01 1.532875000000e-09 8.567795000000e-01 1.534025000000e-09 8.569732000000e-01 1.534117000000e-09 8.553577000000e-01 1.534180000000e-09 8.540555000000e-01 1.534382000000e-09 8.505380000000e-01 1.534737000000e-09 8.467751000000e-01 1.535025000000e-09 8.454186000000e-01 1.535086000000e-09 8.462077000000e-01 1.535120000000e-09 8.466173000000e-01 1.535227000000e-09 8.476897000000e-01 1.535516000000e-09 8.499032000000e-01 1.535770000000e-09 8.515064000000e-01 1.536253000000e-09 8.538933000000e-01 1.537797000000e-09 8.581241000000e-01 1.540037000000e-09 8.595312000000e-01 1.542991000000e-09 8.595640000000e-01 1.546340000000e-09 8.594146000000e-01 1.549563000000e-09 8.593834000000e-01 1.553023000000e-09 8.593813000000e-01 1.556674000000e-09 8.594847000000e-01 1.561332000000e-09 8.596019000000e-01 1.564959000000e-09 8.597225000000e-01 1.568637000000e-09 8.597781000000e-01 1.572862000000e-09 8.598632000000e-01 1.576410000000e-09 8.598787000000e-01 1.580380000000e-09 8.599301000000e-01 1.584817000000e-09 8.599323000000e-01 1.588226000000e-09 8.599649000000e-01 1.592181000000e-09 8.599545000000e-01 1.595925000000e-09 8.599814000000e-01 1.599741000000e-09 8.599661000000e-01 1.604581000000e-09 8.599898000000e-01 1.606342000000e-09 8.599844000000e-01 1.608103000000e-09 8.599716000000e-01 1.611836000000e-09 8.599922000000e-01 1.616035000000e-09 8.599765000000e-01 1.619218000000e-09 8.599939000000e-01 1.623182000000e-09 8.599755000000e-01 1.626358000000e-09 8.599943000000e-01 1.629985000000e-09 8.599762000000e-01 1.634074000000e-09 8.599945000000e-01 1.638238000000e-09 8.599767000000e-01 1.643068000000e-09 8.599948000000e-01 1.648476000000e-09 8.599772000000e-01 1.653917000000e-09 8.599950000000e-01 1.658595000000e-09 8.599775000000e-01 1.665047000000e-09 8.600030000000e-01 1.668427000000e-09 8.599803000000e-01 1.674362000000e-09 8.599975000000e-01 1.678501000000e-09 8.599786000000e-01 1.684581000000e-09 8.599960000000e-01 1.686093000000e-09 8.599874000000e-01 1.687486000000e-09 8.599870000000e-01 1.691945000000e-09 8.599874000000e-01 1.695547000000e-09 8.599872000000e-01 1.700342000000e-09 8.599874000000e-01 1.704014000000e-09 8.599872000000e-01 1.707642000000e-09 8.599874000000e-01 1.712914000000e-09 8.599872000000e-01 1.717024000000e-09 8.599874000000e-01 1.722796000000e-09 8.599872000000e-01 1.724262000000e-09 8.599873000000e-01 1.725743000000e-09 8.599873000000e-01 1.730482000000e-09 8.599873000000e-01 1.734128000000e-09 8.599873000000e-01 1.739613000000e-09 8.599873000000e-01 1.743241000000e-09 8.599873000000e-01 1.746998000000e-09 8.599873000000e-01 1.752400000000e-09 8.599873000000e-01 1.756586000000e-09 8.599873000000e-01 1.762468000000e-09 8.599873000000e-01 1.764025000000e-09 8.599873000000e-01 1.765380000000e-09 8.599873000000e-01 1.769719000000e-09 8.599873000000e-01 1.773264000000e-09 8.599873000000e-01 1.778028000000e-09 8.599873000000e-01 1.781718000000e-09 8.599873000000e-01 1.785310000000e-09 8.599876000000e-01 1.790811000000e-09 8.599888000000e-01 1.794844000000e-09 8.599870000000e-01 1.800637000000e-09 8.599863000000e-01 1.802097000000e-09 8.599862000000e-01 1.803580000000e-09 8.599856000000e-01 1.808326000000e-09 8.599831000000e-01 1.811970000000e-09 8.599830000000e-01 1.817496000000e-09 8.599814000000e-01 1.821120000000e-09 8.599783000000e-01 1.824884000000e-09 8.600114000000e-01 1.830308000000e-09 8.601108000000e-01 1.834495000000e-09 8.601407000000e-01 1.840377000000e-09 8.600745000000e-01 1.841939000000e-09 8.600106000000e-01 1.843284000000e-09 8.599279000000e-01 1.847586000000e-09 8.593915000000e-01 1.851115000000e-09 8.587819000000e-01 1.855851000000e-09 8.575589000000e-01 1.859543000000e-09 8.559020000000e-01 1.863125000000e-09 8.560960000000e-01 1.868621000000e-09 8.699287000000e-01 1.872640000000e-09 8.890180000000e-01 1.878406000000e-09 9.071734000000e-01 1.879857000000e-09 9.034499000000e-01 1.881342000000e-09 8.948587000000e-01 1.886097000000e-09 7.978666000000e-01 1.889729000000e-09 6.612795000000e-01 1.895406000000e-09 4.149611000000e-01 1.899019000000e-09 2.808790000000e-01 1.902802000000e-09 1.780909000000e-01 1.908327000000e-09 9.522696000000e-02 1.912510000000e-09 6.423967000000e-02 1.918396000000e-09 3.786923000000e-02 1.923452000000e-09 2.262383000000e-02 1.928319000000e-09 1.165636000000e-02 1.933832000000e-09 4.932526000000e-03 1.937865000000e-09 2.595552000000e-03 1.941516000000e-09 1.469566000000e-03 1.947123000000e-09 5.756111000000e-04 1.951206000000e-09 3.159608000000e-04 1.957151000000e-09 1.154964000000e-04 1.962202000000e-09 6.308505000000e-05 1.967100000000e-09 1.982210000000e-05 1.968013000000e-09 2.543659000000e-05 1.969099000000e-09 2.068749000000e-05 1.972453000000e-09 3.028874000000e-05 1.975701000000e-09 1.967898000000e-05 1.979195000000e-09 1.319057000000e-05 1.983866000000e-09 8.389155000000e-06 1.987814000000e-09 6.623451000000e-06 1.993099000000e-09 5.146918000000e-06 1.998488000000e-09 4.557641000000e-06 2.003935000000e-09 4.154266000000e-06 2.004866000000e-09 4.154688000000e-06 2.005730000000e-09 4.164186000000e-06 2.008495000000e-09 4.053755000000e-06 2.013208000000e-09 3.961943000000e-06 2.016501000000e-09 3.922034000000e-06 2.021215000000e-09 3.902688000000e-06 2.025252000000e-09 3.888352000000e-06 2.030301000000e-09 3.880914000000e-06 2.035760000000e-09 3.870448000000e-06 2.040977000000e-09 3.871666000000e-06 2.042009000000e-09 3.869134000000e-06 2.042812000000e-09 3.868673000000e-06 2.045379000000e-09 3.867808000000e-06 2.049639000000e-09 3.866496000000e-06 2.053254000000e-09 3.866272000000e-06 2.056728000000e-09 3.865821000000e-06 2.062152000000e-09 3.865597000000e-06 2.066039000000e-09 3.865273000000e-06 2.071558000000e-09 3.865208000000e-06 2.076872000000e-09 3.865069000000e-06 2.078300000000e-09 3.865110000000e-06 2.079144000000e-09 3.865107000000e-06 2.081843000000e-09 3.865086000000e-06 2.085459000000e-09 3.865072000000e-06 2.089564000000e-09 3.865063000000e-06 2.093109000000e-09 3.865060000000e-06 2.096789000000e-09 3.865054000000e-06 2.101106000000e-09 3.865051000000e-06 2.105378000000e-09 3.865048000000e-06 2.110838000000e-09 3.865049000000e-06 2.112251000000e-09 3.865048000000e-06 2.113753000000e-09 3.865048000000e-06 2.118558000000e-09 3.865047000000e-06 2.122133000000e-09 3.865047000000e-06 2.129360000000e-09 3.865047000000e-06 2.132821000000e-09 3.865046000000e-06 2.136929000000e-09 3.865046000000e-06 2.139763000000e-09 3.865046000000e-06 2.142597000000e-09 3.865046000000e-06 2.147012000000e-09 3.865046000000e-06 2.152765000000e-09 3.865046000000e-06 2.154377000000e-09 3.865046000000e-06 2.155442000000e-09 3.865046000000e-06 2.158852000000e-09 3.865046000000e-06 2.162621000000e-09 3.865046000000e-06 2.166944000000e-09 3.865046000000e-06 2.170618000000e-09 3.865046000000e-06 2.174167000000e-09 3.865046000000e-06 2.179170000000e-09 3.865046000000e-06 2.183292000000e-09 3.865046000000e-06 2.188867000000e-09 3.865047000000e-06 2.190278000000e-09 3.865046000000e-06 2.191779000000e-09 3.865046000000e-06 2.196584000000e-09 3.865047000000e-06 2.200169000000e-09 3.865047000000e-06 2.207050000000e-09 3.865047000000e-06 2.210543000000e-09 3.865047000000e-06 2.214570000000e-09 3.865047000000e-06 2.217383000000e-09 3.865047000000e-06 2.220196000000e-09 3.865047000000e-06 2.224548000000e-09 3.865047000000e-06 2.230327000000e-09 3.865047000000e-06 2.231668000000e-09 3.865047000000e-06 2.232487000000e-09 3.865047000000e-06 2.235108000000e-09 3.865047000000e-06 2.238430000000e-09 3.865047000000e-06 2.242101000000e-09 3.865047000000e-06 2.245250000000e-09 3.865047000000e-06 2.248623000000e-09 3.865047000000e-06 2.252399000000e-09 3.865047000000e-06 2.256336000000e-09 3.865047000000e-06 2.261919000000e-09 3.865047000000e-06 2.264384000000e-09 3.865047000000e-06 2.265883000000e-09 3.865047000000e-06 2.270679000000e-09 3.865047000000e-06 2.277378000000e-09 3.865047000000e-06 2.283984000000e-09 3.865047000000e-06 2.291963000000e-09 3.865047000000e-06 2.303337000000e-09 3.865047000000e-06 2.323042000000e-09 3.865047000000e-06 2.352076000000e-09 3.865047000000e-06 2.407975000000e-09 3.865047000000e-06 2.543499000000e-09 3.865047000000e-06 2.778736000000e-09 3.865080000000e-06 3.128736000000e-09 3.864973000000e-06 3.478736000000e-09 3.865159000000e-06 3.828736000000e-09 3.864902000000e-06 4.076000000000e-09 3.865234000000e-06 4.076500000000e-09 2.038000000000e-02 4.077000000000e-09 4.007088000000e-02 4.077306000000e-09 3.904898000000e-02 4.077515000000e-09 3.825152000000e-02 4.078112000000e-09 3.571189000000e-02 4.079900000000e-09 2.850047000000e-02 4.082540000000e-09 1.955123000000e-02 4.086501000000e-09 1.040439000000e-02 4.092049000000e-09 3.783348000000e-03 4.100074000000e-09 6.728565000000e-04 4.112222000000e-09 -3.187791000000e-05 4.128358000000e-09 2.202209000000e-05 4.151784000000e-09 -4.242876000000e-06 4.181738000000e-09 1.638202000000e-05 4.223091000000e-09 -1.068104000000e-06 4.287381000000e-09 1.500031000000e-05 4.412795000000e-09 -6.956760000000e-07 4.639879000000e-09 1.497459000000e-05 4.989879000000e-09 -1.114073000000e-06 5.339879000000e-09 1.533506000000e-05 5.689879000000e-09 -1.414921000000e-06 6.039879000000e-09 1.562722000000e-05 6.389879000000e-09 -1.716015000000e-06 6.739879000000e-09 1.588196000000e-05 7.000000000000e-09 -2.005696000000e-06)
V_XOR_21 xor_21 0 PWL(0.000000000000e+00 6.995221000000e-06 1.000000000000e-12 6.997984000000e-06 2.000000000000e-12 7.000502000000e-06 5.200000000000e-12 7.006871000000e-06 1.544000000000e-11 7.014253000000e-06 4.820800000000e-11 7.014547000000e-06 1.530656000000e-10 7.014629000000e-06 4.886099000000e-10 7.014537000000e-06 8.386099000000e-10 7.014631000000e-06 9.995000000000e-10 7.014537000000e-06 9.996500000000e-10 7.014541000000e-06 1.000130000000e-09 7.014550000000e-06 1.000271000000e-09 7.014553000000e-06 1.000500000000e-09 7.014556000000e-06 1.000549000000e-09 7.014557000000e-06 1.000579000000e-09 7.014557000000e-06 1.000674000000e-09 7.014559000000e-06 1.000921000000e-09 7.014561000000e-06 1.001177000000e-09 7.014564000000e-06 1.001636000000e-09 7.014567000000e-06 1.002995000000e-09 7.014574000000e-06 1.004717000000e-09 7.014578000000e-06 1.007157000000e-09 7.014583000000e-06 1.009530000000e-09 7.014585000000e-06 1.012064000000e-09 7.014586000000e-06 1.014479000000e-09 7.014587000000e-06 1.016999000000e-09 7.014587000000e-06 1.019780000000e-09 7.014587000000e-06 1.023006000000e-09 7.014586000000e-06 1.025715000000e-09 7.014586000000e-06 1.028767000000e-09 7.014585000000e-06 1.031545000000e-09 7.014585000000e-06 1.034548000000e-09 7.014585000000e-06 1.037295000000e-09 7.014585000000e-06 1.040188000000e-09 7.014584000000e-06 1.042931000000e-09 7.014584000000e-06 1.046095000000e-09 7.014584000000e-06 1.049020000000e-09 7.014584000000e-06 1.051920000000e-09 7.014584000000e-06 1.055268000000e-09 7.014584000000e-06 1.057963000000e-09 7.014584000000e-06 1.059420000000e-09 7.014584000000e-06 1.060877000000e-09 7.014584000000e-06 1.063981000000e-09 7.014584000000e-06 1.066813000000e-09 7.014584000000e-06 1.069715000000e-09 7.014584000000e-06 1.073141000000e-09 7.014584000000e-06 1.075000000000e-09 7.014584000000e-06 1.075500000000e-09 -2.045888000000e-02 1.075834000000e-09 -3.391895000000e-02 1.076000000000e-09 -4.043047000000e-02 1.076266000000e-09 -3.910846000000e-02 1.076419000000e-09 -3.826786000000e-02 1.076822000000e-09 -3.580911000000e-02 1.078112000000e-09 -2.860478000000e-02 1.079915000000e-09 -2.077672000000e-02 1.082834000000e-09 -1.253812000000e-02 1.086452000000e-09 -6.732492000000e-03 1.089863000000e-09 -3.811583000000e-03 1.094093000000e-09 -1.921681000000e-03 1.097558000000e-09 -1.165445000000e-03 1.101264000000e-09 -7.065969000000e-04 1.105520000000e-09 -4.344228000000e-04 1.109056000000e-09 -2.959288000000e-04 1.112992000000e-09 -2.150839000000e-04 1.115807000000e-09 -1.673405000000e-04 1.118621000000e-09 -1.279798000000e-04 1.121942000000e-09 -1.058274000000e-04 1.125724000000e-09 -7.572437000000e-05 1.129501000000e-09 -6.325407000000e-05 1.133249000000e-09 -4.285626000000e-05 1.135809000000e-09 -3.587991000000e-05 1.138369000000e-09 -3.454717000000e-05 1.141791000000e-09 -2.268020000000e-05 1.145734000000e-09 -1.969639000000e-05 1.150017000000e-09 -1.008213000000e-05 1.153865000000e-09 -1.102566000000e-05 1.158361000000e-09 -4.749447000000e-06 1.161824000000e-09 -6.269400000000e-06 1.165535000000e-09 -1.363381000000e-06 1.169527000000e-09 -3.004000000000e-06 1.173109000000e-09 8.421522000000e-07 1.177056000000e-09 -9.417078000000e-07 1.179535000000e-09 1.080576000000e-07 1.182013000000e-09 2.831831000000e-06 1.185429000000e-09 9.489744000000e-07 1.189651000000e-09 3.474935000000e-06 1.193349000000e-09 2.230150000000e-06 1.197208000000e-09 4.177973000000e-06 1.200595000000e-09 2.903837000000e-06 1.204042000000e-09 4.370442000000e-06 1.207661000000e-09 3.378371000000e-06 1.212044000000e-09 4.811622000000e-06 1.215603000000e-09 3.987101000000e-06 1.219624000000e-09 5.079813000000e-06 1.222280000000e-09 5.068909000000e-06 1.224935000000e-09 4.475377000000e-06 1.228316000000e-09 5.352252000000e-06 1.229186000000e-09 5.237903000000e-06 1.230042000000e-09 5.195261000000e-06 1.232779000000e-09 6.109705000000e-06 1.235670000000e-09 6.042910000000e-06 1.238863000000e-09 6.018342000000e-06 1.243639000000e-09 5.931768000000e-06 1.246999000000e-09 5.993830000000e-06 1.250850000000e-09 5.921389000000e-06 1.255187000000e-09 5.993005000000e-06 1.258822000000e-09 5.926268000000e-06 1.259631000000e-09 5.957748000000e-06 1.260438000000e-09 5.962806000000e-06 1.263021000000e-09 5.962821000000e-06 1.265957000000e-09 5.965550000000e-06 1.269137000000e-09 5.963352000000e-06 1.273131000000e-09 5.966357000000e-06 1.276658000000e-09 5.964792000000e-06 1.280195000000e-09 5.967573000000e-06 1.284359000000e-09 5.966149000000e-06 1.288216000000e-09 5.968612000000e-06 1.291735000000e-09 5.967080000000e-06 1.292574000000e-09 5.968035000000e-06 1.293423000000e-09 5.968186000000e-06 1.296139000000e-09 5.968327000000e-06 1.299136000000e-09 5.968588000000e-06 1.302736000000e-09 5.968719000000e-06 1.306959000000e-09 5.968958000000e-06 1.310392000000e-09 5.969016000000e-06 1.314112000000e-09 5.969171000000e-06 1.317424000000e-09 5.969190000000e-06 1.320972000000e-09 5.969302000000e-06 1.324632000000e-09 5.969307000000e-06 1.327145000000e-09 5.969343000000e-06 1.329658000000e-09 5.969407000000e-06 1.333049000000e-09 5.969391000000e-06 1.337028000000e-09 5.969458000000e-06 1.341293000000e-09 5.969447000000e-06 1.345153000000e-09 5.969487000000e-06 1.349994000000e-09 5.969482000000e-06 1.353616000000e-09 5.969541000000e-06 1.357116000000e-09 5.969306000000e-06 1.357983000000e-09 5.969580000000e-06 1.358962000000e-09 5.969698000000e-06 1.362092000000e-09 5.969473000000e-06 1.364885000000e-09 5.969456000000e-06 1.369987000000e-09 5.969630000000e-06 1.373500000000e-09 5.972850000000e-06 1.377230000000e-09 5.957407000000e-06 1.381288000000e-09 5.978918000000e-06 1.384815000000e-09 5.970125000000e-06 1.388662000000e-09 5.968284000000e-06 1.389532000000e-09 5.975883000000e-06 1.390483000000e-09 5.990462000000e-06 1.393528000000e-09 6.357009000000e-06 1.396267000000e-09 5.633694000000e-06 1.399530000000e-09 5.723475000000e-06 1.403009000000e-09 5.780399000000e-06 1.406745000000e-09 5.777135000000e-06 1.410579000000e-09 6.007961000000e-06 1.413057000000e-09 7.833031000000e-06 1.415535000000e-09 1.097409000000e-05 1.418933000000e-09 2.791107000000e-05 1.419781000000e-09 2.456706000000e-05 1.420563000000e-09 2.120776000000e-05 1.423064000000e-09 6.659246000000e-07 1.426220000000e-09 -3.550272000000e-05 1.429627000000e-09 -9.231637000000e-05 1.432942000000e-09 -4.253411000000e-05 1.436511000000e-09 4.324438000000e-04 1.439973000000e-09 1.181705000000e-03 1.444113000000e-09 8.019526000000e-04 1.447667000000e-09 -3.604953000000e-03 1.448597000000e-09 -5.810400000000e-03 1.449278000000e-09 -7.519722000000e-03 1.451458000000e-09 -1.412195000000e-02 1.454984000000e-09 -2.222829000000e-02 1.458241000000e-09 -5.140353000000e-03 1.461761000000e-09 6.176712000000e-02 1.465886000000e-09 1.740329000000e-01 1.469389000000e-09 2.608935000000e-01 1.472794000000e-09 3.327803000000e-01 1.475276000000e-09 3.873962000000e-01 1.477758000000e-09 4.438823000000e-01 1.479095000000e-09 4.757448000000e-01 1.479882000000e-09 4.944778000000e-01 1.482402000000e-09 5.525359000000e-01 1.485321000000e-09 6.127314000000e-01 1.488790000000e-09 6.698053000000e-01 1.492381000000e-09 7.127237000000e-01 1.496661000000e-09 7.479364000000e-01 1.500576000000e-09 7.709258000000e-01 1.504103000000e-09 7.884621000000e-01 1.508121000000e-09 8.062120000000e-01 1.509046000000e-09 8.097272000000e-01 1.509764000000e-09 8.123941000000e-01 1.512062000000e-09 8.201594000000e-01 1.514727000000e-09 8.277433000000e-01 1.518391000000e-09 8.357648000000e-01 1.521668000000e-09 8.408574000000e-01 1.525243000000e-09 8.448710000000e-01 1.529365000000e-09 8.483475000000e-01 1.532875000000e-09 8.506304000000e-01 1.534025000000e-09 8.512564000000e-01 1.534117000000e-09 8.495381000000e-01 1.534180000000e-09 8.484251000000e-01 1.534382000000e-09 8.454833000000e-01 1.534737000000e-09 8.412495000000e-01 1.535025000000e-09 8.394873000000e-01 1.535086000000e-09 8.400589000000e-01 1.535120000000e-09 8.403858000000e-01 1.535227000000e-09 8.412395000000e-01 1.535516000000e-09 8.429630000000e-01 1.535770000000e-09 8.442658000000e-01 1.536253000000e-09 8.462840000000e-01 1.537797000000e-09 8.503796000000e-01 1.540037000000e-09 8.528477000000e-01 1.542991000000e-09 8.545724000000e-01 1.546340000000e-09 8.557345000000e-01 1.549563000000e-09 8.566343000000e-01 1.553023000000e-09 8.573898000000e-01 1.556674000000e-09 8.580852000000e-01 1.561332000000e-09 8.586910000000e-01 1.564959000000e-09 8.590849000000e-01 1.568637000000e-09 8.593197000000e-01 1.572862000000e-09 8.595639000000e-01 1.576410000000e-09 8.596566000000e-01 1.580380000000e-09 8.597849000000e-01 1.584817000000e-09 8.598279000000e-01 1.588226000000e-09 8.598971000000e-01 1.592181000000e-09 8.598982000000e-01 1.595925000000e-09 8.599510000000e-01 1.599741000000e-09 8.599352000000e-01 1.604581000000e-09 8.599792000000e-01 1.606342000000e-09 8.599731000000e-01 1.608103000000e-09 8.599552000000e-01 1.611836000000e-09 8.599903000000e-01 1.616035000000e-09 8.599640000000e-01 1.619218000000e-09 8.599946000000e-01 1.623182000000e-09 8.599676000000e-01 1.626358000000e-09 8.599968000000e-01 1.629985000000e-09 8.599695000000e-01 1.634074000000e-09 8.600035000000e-01 1.638238000000e-09 8.599721000000e-01 1.643068000000e-09 8.600012000000e-01 1.648476000000e-09 8.599723000000e-01 1.653917000000e-09 8.600004000000e-01 1.658595000000e-09 8.599724000000e-01 1.665047000000e-09 8.600027000000e-01 1.668427000000e-09 8.599733000000e-01 1.674362000000e-09 8.600014000000e-01 1.678501000000e-09 8.599731000000e-01 1.684581000000e-09 8.600014000000e-01 1.686093000000e-09 8.599874000000e-01 1.687486000000e-09 8.599873000000e-01 1.691945000000e-09 8.599873000000e-01 1.695547000000e-09 8.599873000000e-01 1.700342000000e-09 8.599873000000e-01 1.704014000000e-09 8.599873000000e-01 1.707642000000e-09 8.599873000000e-01 1.712914000000e-09 8.599873000000e-01 1.717024000000e-09 8.599873000000e-01 1.722796000000e-09 8.599873000000e-01 1.724262000000e-09 8.599873000000e-01 1.725743000000e-09 8.599873000000e-01 1.730482000000e-09 8.599873000000e-01 1.734128000000e-09 8.599873000000e-01 1.739613000000e-09 8.599873000000e-01 1.743241000000e-09 8.599873000000e-01 1.746998000000e-09 8.599873000000e-01 1.752400000000e-09 8.599873000000e-01 1.756586000000e-09 8.599873000000e-01 1.762468000000e-09 8.599873000000e-01 1.764025000000e-09 8.599873000000e-01 1.765380000000e-09 8.599873000000e-01 1.769719000000e-09 8.599873000000e-01 1.773264000000e-09 8.599873000000e-01 1.778028000000e-09 8.599873000000e-01 1.781718000000e-09 8.599873000000e-01 1.785310000000e-09 8.599873000000e-01 1.790811000000e-09 8.599873000000e-01 1.794844000000e-09 8.599873000000e-01 1.800637000000e-09 8.599873000000e-01 1.802097000000e-09 8.599873000000e-01 1.803580000000e-09 8.599873000000e-01 1.808326000000e-09 8.599873000000e-01 1.811970000000e-09 8.599873000000e-01 1.817496000000e-09 8.599873000000e-01 1.821120000000e-09 8.599873000000e-01 1.824884000000e-09 8.599877000000e-01 1.830308000000e-09 8.599878000000e-01 1.834495000000e-09 8.599871000000e-01 1.840377000000e-09 8.599864000000e-01 1.841939000000e-09 8.599861000000e-01 1.843284000000e-09 8.599855000000e-01 1.847586000000e-09 8.599830000000e-01 1.851115000000e-09 8.599831000000e-01 1.855851000000e-09 8.599820000000e-01 1.859543000000e-09 8.599776000000e-01 1.863125000000e-09 8.600019000000e-01 1.868621000000e-09 8.600988000000e-01 1.872640000000e-09 8.601405000000e-01 1.878406000000e-09 8.601009000000e-01 1.879857000000e-09 8.600601000000e-01 1.881342000000e-09 8.599892000000e-01 1.886097000000e-09 8.594501000000e-01 1.889729000000e-09 8.588328000000e-01 1.895406000000e-09 8.572770000000e-01 1.899019000000e-09 8.556611000000e-01 1.902802000000e-09 8.569129000000e-01 1.908327000000e-09 8.731736000000e-01 1.912510000000e-09 8.934529000000e-01 1.918396000000e-09 9.043527000000e-01 1.923452000000e-09 8.396530000000e-01 1.928319000000e-09 6.753626000000e-01 1.933832000000e-09 4.349449000000e-01 1.937865000000e-09 2.831480000000e-01 1.941516000000e-09 1.826277000000e-01 1.947123000000e-09 9.639793000000e-02 1.951206000000e-09 6.557359000000e-02 1.957151000000e-09 3.841784000000e-02 1.962202000000e-09 2.308854000000e-02 1.967100000000e-09 1.190801000000e-02 1.968013000000e-09 1.050874000000e-02 1.969099000000e-09 8.958427000000e-03 1.972453000000e-09 5.375564000000e-03 1.975701000000e-09 3.254022000000e-03 1.979195000000e-09 1.882176000000e-03 1.983866000000e-09 8.864341000000e-04 1.987814000000e-09 4.778119000000e-04 1.993099000000e-09 2.081376000000e-04 1.998488000000e-09 9.114252000000e-05 2.003935000000e-09 4.145116000000e-05 2.004866000000e-09 3.776819000000e-05 2.005730000000e-09 3.459693000000e-05 2.008495000000e-09 2.643810000000e-05 2.013208000000e-09 1.780000000000e-05 2.016501000000e-09 1.333461000000e-05 2.021215000000e-09 9.985946000000e-06 2.025252000000e-09 8.553673000000e-06 2.030301000000e-09 7.510855000000e-06 2.035760000000e-09 6.855247000000e-06 2.040977000000e-09 6.570454000000e-06 2.042009000000e-09 6.534334000000e-06 2.042812000000e-09 6.509982000000e-06 2.045379000000e-09 6.437003000000e-06 2.049639000000e-09 6.337143000000e-06 2.053254000000e-09 6.291923000000e-06 2.056728000000e-09 6.265214000000e-06 2.062152000000e-09 6.247440000000e-06 2.066039000000e-09 6.240028000000e-06 2.071558000000e-09 6.230789000000e-06 2.076872000000e-09 6.226501000000e-06 2.078300000000e-09 6.226117000000e-06 2.079144000000e-09 6.225800000000e-06 2.081843000000e-09 6.224721000000e-06 2.085459000000e-09 6.223526000000e-06 2.089564000000e-09 6.222728000000e-06 2.093109000000e-09 6.222353000000e-06 2.096789000000e-09 6.222099000000e-06 2.101106000000e-09 6.221837000000e-06 2.105378000000e-09 6.221609000000e-06 2.110838000000e-09 6.221471000000e-06 2.112251000000e-09 6.221460000000e-06 2.113753000000e-09 6.221451000000e-06 2.118558000000e-09 6.221415000000e-06 2.122133000000e-09 6.221394000000e-06 2.129360000000e-09 6.221375000000e-06 2.132821000000e-09 6.221373000000e-06 2.136929000000e-09 6.221368000000e-06 2.139763000000e-09 6.221365000000e-06 2.142597000000e-09 6.221363000000e-06 2.147012000000e-09 6.221363000000e-06 2.152765000000e-09 6.221362000000e-06 2.154377000000e-09 6.221362000000e-06 2.155442000000e-09 6.221362000000e-06 2.158852000000e-09 6.221362000000e-06 2.162621000000e-09 6.221361000000e-06 2.166944000000e-09 6.221361000000e-06 2.170618000000e-09 6.221361000000e-06 2.174167000000e-09 6.221361000000e-06 2.179170000000e-09 6.221361000000e-06 2.183292000000e-09 6.221361000000e-06 2.188867000000e-09 6.221361000000e-06 2.190278000000e-09 6.221361000000e-06 2.191779000000e-09 6.221361000000e-06 2.196584000000e-09 6.221361000000e-06 2.200169000000e-09 6.221361000000e-06 2.207050000000e-09 6.221361000000e-06 2.210543000000e-09 6.221361000000e-06 2.214570000000e-09 6.221361000000e-06 2.217383000000e-09 6.221361000000e-06 2.220196000000e-09 6.221361000000e-06 2.224548000000e-09 6.221361000000e-06 2.230327000000e-09 6.221361000000e-06 2.231668000000e-09 6.221361000000e-06 2.232487000000e-09 6.221361000000e-06 2.235108000000e-09 6.221361000000e-06 2.238430000000e-09 6.221361000000e-06 2.242101000000e-09 6.221361000000e-06 2.245250000000e-09 6.221361000000e-06 2.248623000000e-09 6.221361000000e-06 2.252399000000e-09 6.221361000000e-06 2.256336000000e-09 6.221361000000e-06 2.261919000000e-09 6.221361000000e-06 2.264384000000e-09 6.221361000000e-06 2.265883000000e-09 6.221361000000e-06 2.270679000000e-09 6.221361000000e-06 2.277378000000e-09 6.221361000000e-06 2.283984000000e-09 6.221361000000e-06 2.291963000000e-09 6.221361000000e-06 2.303337000000e-09 6.221361000000e-06 2.323042000000e-09 6.221361000000e-06 2.352076000000e-09 6.221361000000e-06 2.407975000000e-09 6.221361000000e-06 2.543499000000e-09 6.221361000000e-06 2.778736000000e-09 6.221362000000e-06 3.128736000000e-09 6.221362000000e-06 3.478736000000e-09 6.221362000000e-06 3.828736000000e-09 6.221362000000e-06 4.076000000000e-09 6.221362000000e-06 4.076500000000e-09 2.037901000000e-02 4.077000000000e-09 4.007024000000e-02 4.077306000000e-09 3.904853000000e-02 4.077515000000e-09 3.825117000000e-02 4.078112000000e-09 3.571178000000e-02 4.079900000000e-09 2.850068000000e-02 4.082540000000e-09 1.955143000000e-02 4.086501000000e-09 1.040449000000e-02 4.092049000000e-09 3.783387000000e-03 4.100074000000e-09 6.728626000000e-04 4.112222000000e-09 -3.187709000000e-05 4.128358000000e-09 2.202145000000e-05 4.151784000000e-09 -4.242553000000e-06 4.181738000000e-09 1.638173000000e-05 4.223091000000e-09 -1.068075000000e-06 4.287381000000e-09 1.500009000000e-05 4.412795000000e-09 -6.957272000000e-07 4.639879000000e-09 1.497441000000e-05 4.989879000000e-09 -1.114140000000e-06 5.339879000000e-09 1.533487000000e-05 5.689879000000e-09 -1.414982000000e-06 6.039879000000e-09 1.562701000000e-05 6.389879000000e-09 -1.716077000000e-06 6.739879000000e-09 1.588175000000e-05 7.000000000000e-09 -2.005761000000e-06)
V_XOR_22 xor_22 0 PWL(0.000000000000e+00 6.995221000000e-06 1.000000000000e-12 6.997984000000e-06 2.000000000000e-12 7.000502000000e-06 5.200000000000e-12 7.006871000000e-06 1.544000000000e-11 7.014253000000e-06 4.820800000000e-11 7.014547000000e-06 1.530656000000e-10 7.014629000000e-06 4.886099000000e-10 7.014537000000e-06 8.386099000000e-10 7.014631000000e-06 9.995000000000e-10 7.014537000000e-06 9.996500000000e-10 7.014541000000e-06 1.000130000000e-09 7.014550000000e-06 1.000271000000e-09 7.014553000000e-06 1.000500000000e-09 7.014556000000e-06 1.000549000000e-09 7.014557000000e-06 1.000579000000e-09 7.014557000000e-06 1.000674000000e-09 7.014559000000e-06 1.000921000000e-09 7.014561000000e-06 1.001177000000e-09 7.014564000000e-06 1.001636000000e-09 7.014567000000e-06 1.002995000000e-09 7.014574000000e-06 1.004717000000e-09 7.014578000000e-06 1.007157000000e-09 7.014583000000e-06 1.009530000000e-09 7.014585000000e-06 1.012064000000e-09 7.014586000000e-06 1.014479000000e-09 7.014587000000e-06 1.016999000000e-09 7.014587000000e-06 1.019780000000e-09 7.014587000000e-06 1.023006000000e-09 7.014586000000e-06 1.025715000000e-09 7.014586000000e-06 1.028767000000e-09 7.014585000000e-06 1.031545000000e-09 7.014585000000e-06 1.034548000000e-09 7.014585000000e-06 1.037295000000e-09 7.014585000000e-06 1.040188000000e-09 7.014584000000e-06 1.042931000000e-09 7.014584000000e-06 1.046095000000e-09 7.014584000000e-06 1.049020000000e-09 7.014584000000e-06 1.051920000000e-09 7.014584000000e-06 1.055268000000e-09 7.014584000000e-06 1.057963000000e-09 7.014584000000e-06 1.059420000000e-09 7.014584000000e-06 1.060877000000e-09 7.014584000000e-06 1.063981000000e-09 7.014584000000e-06 1.066813000000e-09 7.014584000000e-06 1.069715000000e-09 7.014584000000e-06 1.073141000000e-09 7.014584000000e-06 1.075000000000e-09 7.014584000000e-06 1.075500000000e-09 -2.045888000000e-02 1.075834000000e-09 -3.391895000000e-02 1.076000000000e-09 -4.043047000000e-02 1.076266000000e-09 -3.910846000000e-02 1.076419000000e-09 -3.826786000000e-02 1.076822000000e-09 -3.580911000000e-02 1.078112000000e-09 -2.860478000000e-02 1.079915000000e-09 -2.077672000000e-02 1.082834000000e-09 -1.253812000000e-02 1.086452000000e-09 -6.732492000000e-03 1.089863000000e-09 -3.811583000000e-03 1.094093000000e-09 -1.921681000000e-03 1.097558000000e-09 -1.165445000000e-03 1.101264000000e-09 -7.065969000000e-04 1.105520000000e-09 -4.344228000000e-04 1.109056000000e-09 -2.959288000000e-04 1.112992000000e-09 -2.150839000000e-04 1.115807000000e-09 -1.673405000000e-04 1.118621000000e-09 -1.279798000000e-04 1.121942000000e-09 -1.058274000000e-04 1.125724000000e-09 -7.572437000000e-05 1.129501000000e-09 -6.325407000000e-05 1.133249000000e-09 -4.285626000000e-05 1.135809000000e-09 -3.587991000000e-05 1.138369000000e-09 -3.454717000000e-05 1.141791000000e-09 -2.268020000000e-05 1.145734000000e-09 -1.969639000000e-05 1.150017000000e-09 -1.008213000000e-05 1.153865000000e-09 -1.102566000000e-05 1.158361000000e-09 -4.749447000000e-06 1.161824000000e-09 -6.269400000000e-06 1.165535000000e-09 -1.363381000000e-06 1.169527000000e-09 -3.004000000000e-06 1.173109000000e-09 8.421522000000e-07 1.177056000000e-09 -9.417078000000e-07 1.179535000000e-09 1.080576000000e-07 1.182013000000e-09 2.831831000000e-06 1.185429000000e-09 9.489744000000e-07 1.189651000000e-09 3.474935000000e-06 1.193349000000e-09 2.230150000000e-06 1.197208000000e-09 4.177973000000e-06 1.200595000000e-09 2.903837000000e-06 1.204042000000e-09 4.370442000000e-06 1.207661000000e-09 3.378371000000e-06 1.212044000000e-09 4.811622000000e-06 1.215603000000e-09 3.987101000000e-06 1.219624000000e-09 5.079813000000e-06 1.222280000000e-09 5.068909000000e-06 1.224935000000e-09 4.475377000000e-06 1.228316000000e-09 5.352252000000e-06 1.229186000000e-09 5.237903000000e-06 1.230042000000e-09 5.195261000000e-06 1.232779000000e-09 6.109705000000e-06 1.235670000000e-09 6.042910000000e-06 1.238863000000e-09 6.018342000000e-06 1.243639000000e-09 5.931768000000e-06 1.246999000000e-09 5.993830000000e-06 1.250850000000e-09 5.921389000000e-06 1.255187000000e-09 5.993005000000e-06 1.258822000000e-09 5.926268000000e-06 1.259631000000e-09 5.957748000000e-06 1.260438000000e-09 5.962806000000e-06 1.263021000000e-09 5.962821000000e-06 1.265957000000e-09 5.965550000000e-06 1.269137000000e-09 5.963352000000e-06 1.273131000000e-09 5.966357000000e-06 1.276658000000e-09 5.964792000000e-06 1.280195000000e-09 5.967573000000e-06 1.284359000000e-09 5.966149000000e-06 1.288216000000e-09 5.968612000000e-06 1.291735000000e-09 5.967080000000e-06 1.292574000000e-09 5.968035000000e-06 1.293423000000e-09 5.968186000000e-06 1.296139000000e-09 5.968327000000e-06 1.299136000000e-09 5.968588000000e-06 1.302736000000e-09 5.968719000000e-06 1.306959000000e-09 5.968958000000e-06 1.310392000000e-09 5.969016000000e-06 1.314112000000e-09 5.969171000000e-06 1.317424000000e-09 5.969190000000e-06 1.320972000000e-09 5.969303000000e-06 1.324632000000e-09 5.969306000000e-06 1.327145000000e-09 5.969343000000e-06 1.329658000000e-09 5.969407000000e-06 1.333049000000e-09 5.969391000000e-06 1.337028000000e-09 5.969460000000e-06 1.341293000000e-09 5.969441000000e-06 1.345153000000e-09 5.969496000000e-06 1.349994000000e-09 5.969473000000e-06 1.353616000000e-09 5.969518000000e-06 1.357116000000e-09 5.969487000000e-06 1.357983000000e-09 5.969511000000e-06 1.358962000000e-09 5.969514000000e-06 1.362092000000e-09 5.969509000000e-06 1.364885000000e-09 5.969518000000e-06 1.369987000000e-09 5.969523000000e-06 1.373500000000e-09 5.969560000000e-06 1.377230000000e-09 5.969335000000e-06 1.381288000000e-09 5.969855000000e-06 1.384815000000e-09 5.969304000000e-06 1.388662000000e-09 5.969556000000e-06 1.389532000000e-09 5.969680000000e-06 1.390483000000e-09 5.969910000000e-06 1.393528000000e-09 5.973881000000e-06 1.396267000000e-09 5.954447000000e-06 1.399530000000e-09 5.977928000000e-06 1.403009000000e-09 5.971741000000e-06 1.406745000000e-09 5.968165000000e-06 1.410579000000e-09 5.972043000000e-06 1.413057000000e-09 6.056967000000e-06 1.415535000000e-09 6.206610000000e-06 1.418933000000e-09 5.679736000000e-06 1.419781000000e-09 5.688439000000e-06 1.420563000000e-09 5.714310000000e-06 1.423064000000e-09 5.737809000000e-06 1.426220000000e-09 5.728743000000e-06 1.429627000000e-09 5.641068000000e-06 1.432942000000e-09 6.950380000000e-06 1.436511000000e-09 1.127796000000e-05 1.439973000000e-09 2.792903000000e-05 1.444113000000e-09 3.129991000000e-06 1.447667000000e-09 -3.726439000000e-05 1.448597000000e-09 -5.432470000000e-05 1.449278000000e-09 -6.289883000000e-05 1.451458000000e-09 -9.447834000000e-05 1.454984000000e-09 2.392849000000e-05 1.458241000000e-09 5.533085000000e-04 1.461761000000e-09 1.278628000000e-03 1.465886000000e-09 3.706406000000e-04 1.469389000000e-09 -4.776694000000e-03 1.472794000000e-09 -1.476187000000e-02 1.475276000000e-09 -1.641674000000e-02 1.477758000000e-09 -1.333015000000e-02 1.479095000000e-09 -1.812449000000e-04 1.479882000000e-09 9.135118000000e-03 1.482402000000e-09 5.675627000000e-02 1.485321000000e-09 1.333409000000e-01 1.488790000000e-09 2.245577000000e-01 1.492381000000e-09 3.038679000000e-01 1.496661000000e-09 3.955375000000e-01 1.500576000000e-09 4.875281000000e-01 1.504103000000e-09 5.683366000000e-01 1.508121000000e-09 6.448363000000e-01 1.509046000000e-09 6.588901000000e-01 1.509764000000e-09 6.693772000000e-01 1.512062000000e-09 6.985703000000e-01 1.514727000000e-09 7.252520000000e-01 1.518391000000e-09 7.525595000000e-01 1.521668000000e-09 7.712799000000e-01 1.525243000000e-09 7.891153000000e-01 1.529365000000e-09 8.072172000000e-01 1.532875000000e-09 8.197529000000e-01 1.534025000000e-09 8.232417000000e-01 1.534117000000e-09 8.213867000000e-01 1.534180000000e-09 8.201855000000e-01 1.534382000000e-09 8.170150000000e-01 1.534737000000e-09 8.135273000000e-01 1.535025000000e-09 8.120749000000e-01 1.535086000000e-09 8.125303000000e-01 1.535120000000e-09 8.127843000000e-01 1.535227000000e-09 8.134614000000e-01 1.535516000000e-09 8.149498000000e-01 1.535770000000e-09 8.161813000000e-01 1.536253000000e-09 8.183459000000e-01 1.537797000000e-09 8.242837000000e-01 1.540037000000e-09 8.309898000000e-01 1.542991000000e-09 8.376806000000e-01 1.546340000000e-09 8.433037000000e-01 1.549563000000e-09 8.473513000000e-01 1.553023000000e-09 8.506317000000e-01 1.556674000000e-09 8.532278000000e-01 1.561332000000e-09 8.555748000000e-01 1.564959000000e-09 8.568407000000e-01 1.568637000000e-09 8.577503000000e-01 1.572862000000e-09 8.584856000000e-01 1.576410000000e-09 8.589052000000e-01 1.580380000000e-09 8.592452000000e-01 1.584817000000e-09 8.594942000000e-01 1.588226000000e-09 8.596327000000e-01 1.592181000000e-09 8.597384000000e-01 1.595925000000e-09 8.598160000000e-01 1.599741000000e-09 8.598635000000e-01 1.604581000000e-09 8.599125000000e-01 1.606342000000e-09 8.599230000000e-01 1.608103000000e-09 8.599296000000e-01 1.611836000000e-09 8.599510000000e-01 1.616035000000e-09 8.599588000000e-01 1.619218000000e-09 8.599699000000e-01 1.623182000000e-09 8.599716000000e-01 1.626358000000e-09 8.599792000000e-01 1.629985000000e-09 8.599779000000e-01 1.634074000000e-09 8.599842000000e-01 1.638238000000e-09 8.599819000000e-01 1.643068000000e-09 8.599870000000e-01 1.648476000000e-09 8.599839000000e-01 1.653917000000e-09 8.599883000000e-01 1.658595000000e-09 8.599848000000e-01 1.665047000000e-09 8.599888000000e-01 1.668427000000e-09 8.599851000000e-01 1.674362000000e-09 8.599888000000e-01 1.678501000000e-09 8.599852000000e-01 1.684581000000e-09 8.599889000000e-01 1.686093000000e-09 8.599872000000e-01 1.687486000000e-09 8.599872000000e-01 1.691945000000e-09 8.599873000000e-01 1.695547000000e-09 8.599873000000e-01 1.700342000000e-09 8.599873000000e-01 1.704014000000e-09 8.599873000000e-01 1.707642000000e-09 8.599873000000e-01 1.712914000000e-09 8.599873000000e-01 1.717024000000e-09 8.599873000000e-01 1.722796000000e-09 8.599873000000e-01 1.724262000000e-09 8.599873000000e-01 1.725743000000e-09 8.599873000000e-01 1.730482000000e-09 8.599873000000e-01 1.734128000000e-09 8.599873000000e-01 1.739613000000e-09 8.599873000000e-01 1.743241000000e-09 8.599873000000e-01 1.746998000000e-09 8.599873000000e-01 1.752400000000e-09 8.599873000000e-01 1.756586000000e-09 8.599873000000e-01 1.762468000000e-09 8.599873000000e-01 1.764025000000e-09 8.599873000000e-01 1.765380000000e-09 8.599873000000e-01 1.769719000000e-09 8.599873000000e-01 1.773264000000e-09 8.599873000000e-01 1.778028000000e-09 8.599873000000e-01 1.781718000000e-09 8.599873000000e-01 1.785310000000e-09 8.599873000000e-01 1.790811000000e-09 8.599873000000e-01 1.794844000000e-09 8.599873000000e-01 1.800637000000e-09 8.599873000000e-01 1.802097000000e-09 8.599873000000e-01 1.803580000000e-09 8.599873000000e-01 1.808326000000e-09 8.599873000000e-01 1.811970000000e-09 8.599873000000e-01 1.817496000000e-09 8.599873000000e-01 1.821120000000e-09 8.599873000000e-01 1.824884000000e-09 8.599873000000e-01 1.830308000000e-09 8.599873000000e-01 1.834495000000e-09 8.599873000000e-01 1.840377000000e-09 8.599873000000e-01 1.841939000000e-09 8.599873000000e-01 1.843284000000e-09 8.599873000000e-01 1.847586000000e-09 8.599873000000e-01 1.851115000000e-09 8.599873000000e-01 1.855851000000e-09 8.599873000000e-01 1.859543000000e-09 8.599873000000e-01 1.863125000000e-09 8.599876000000e-01 1.868621000000e-09 8.599882000000e-01 1.872640000000e-09 8.599872000000e-01 1.878406000000e-09 8.599865000000e-01 1.879857000000e-09 8.599863000000e-01 1.881342000000e-09 8.599858000000e-01 1.886097000000e-09 8.599832000000e-01 1.889729000000e-09 8.599831000000e-01 1.895406000000e-09 8.599814000000e-01 1.899019000000e-09 8.599784000000e-01 1.902802000000e-09 8.600132000000e-01 1.908327000000e-09 8.601128000000e-01 1.912510000000e-09 8.601404000000e-01 1.918396000000e-09 8.600694000000e-01 1.923452000000e-09 8.596851000000e-01 1.928319000000e-09 8.589048000000e-01 1.933832000000e-09 8.574669000000e-01 1.937865000000e-09 8.557144000000e-01 1.941516000000e-09 8.566953000000e-01 1.947123000000e-09 8.727483000000e-01 1.951206000000e-09 8.925283000000e-01 1.957151000000e-09 9.047688000000e-01 1.962202000000e-09 8.429140000000e-01 1.967100000000e-09 6.797408000000e-01 1.968013000000e-09 6.402091000000e-01 1.969099000000e-09 5.921373000000e-01 1.972453000000e-09 4.425355000000e-01 1.975701000000e-09 3.167367000000e-01 1.979195000000e-09 2.107195000000e-01 1.983866000000e-09 1.210478000000e-01 1.987814000000e-09 8.097229000000e-02 1.993099000000e-09 4.978243000000e-02 1.998488000000e-09 3.060388000000e-02 2.003935000000e-09 1.591755000000e-02 2.004866000000e-09 1.407525000000e-02 2.005730000000e-09 1.244933000000e-02 2.008495000000e-09 8.283221000000e-03 2.013208000000e-09 3.968720000000e-03 2.016501000000e-09 2.374241000000e-03 2.021215000000e-09 1.110858000000e-03 2.025252000000e-09 5.864381000000e-04 2.030301000000e-09 2.648630000000e-04 2.035760000000e-09 1.141547000000e-04 2.040977000000e-09 5.197408000000e-05 2.042009000000e-09 4.634164000000e-05 2.042812000000e-09 4.232559000000e-05 2.045379000000e-09 3.270372000000e-05 2.049639000000e-09 2.130323000000e-05 2.053254000000e-09 1.588099000000e-05 2.056728000000e-09 1.231468000000e-05 2.062152000000e-09 9.192652000000e-06 2.066039000000e-09 8.144330000000e-06 2.071558000000e-09 7.230885000000e-06 2.076872000000e-09 6.748691000000e-06 2.078300000000e-09 6.690322000000e-06 2.079144000000e-09 6.654626000000e-06 2.081843000000e-09 6.555669000000e-06 2.085459000000e-09 6.452907000000e-06 2.089564000000e-09 6.373188000000e-06 2.093109000000e-09 6.331568000000e-06 2.096789000000e-09 6.309400000000e-06 2.101106000000e-09 6.297005000000e-06 2.105378000000e-09 6.287902000000e-06 2.110838000000e-09 6.279082000000e-06 2.112251000000e-09 6.277947000000e-06 2.113753000000e-09 6.276914000000e-06 2.118558000000e-09 6.274413000000e-06 2.122133000000e-09 6.273006000000e-06 2.129360000000e-09 6.271282000000e-06 2.132821000000e-09 6.271013000000e-06 2.136929000000e-09 6.270768000000e-06 2.139763000000e-09 6.270605000000e-06 2.142597000000e-09 6.270447000000e-06 2.147012000000e-09 6.270291000000e-06 2.152765000000e-09 6.270169000000e-06 2.154377000000e-09 6.270167000000e-06 2.155442000000e-09 6.270153000000e-06 2.158852000000e-09 6.270145000000e-06 2.162621000000e-09 6.270134000000e-06 2.166944000000e-09 6.270125000000e-06 2.170618000000e-09 6.270118000000e-06 2.174167000000e-09 6.270113000000e-06 2.179170000000e-09 6.270107000000e-06 2.183292000000e-09 6.270105000000e-06 2.188867000000e-09 6.270104000000e-06 2.190278000000e-09 6.270107000000e-06 2.191779000000e-09 6.270100000000e-06 2.196584000000e-09 6.270103000000e-06 2.200169000000e-09 6.270101000000e-06 2.207050000000e-09 6.270101000000e-06 2.210543000000e-09 6.270100000000e-06 2.214570000000e-09 6.270100000000e-06 2.217383000000e-09 6.270099000000e-06 2.220196000000e-09 6.270099000000e-06 2.224548000000e-09 6.270099000000e-06 2.230327000000e-09 6.270098000000e-06 2.231668000000e-09 6.270101000000e-06 2.232487000000e-09 6.270096000000e-06 2.235108000000e-09 6.270097000000e-06 2.238430000000e-09 6.270098000000e-06 2.242101000000e-09 6.270098000000e-06 2.245250000000e-09 6.270097000000e-06 2.248623000000e-09 6.270097000000e-06 2.252399000000e-09 6.270097000000e-06 2.256336000000e-09 6.270097000000e-06 2.261919000000e-09 6.270096000000e-06 2.264384000000e-09 6.270098000000e-06 2.265883000000e-09 6.270097000000e-06 2.270679000000e-09 6.270092000000e-06 2.277378000000e-09 6.270098000000e-06 2.283984000000e-09 6.270095000000e-06 2.291963000000e-09 6.270095000000e-06 2.303337000000e-09 6.270094000000e-06 2.323042000000e-09 6.270093000000e-06 2.352076000000e-09 6.270092000000e-06 2.407975000000e-09 6.270091000000e-06 2.543499000000e-09 6.270087000000e-06 2.778736000000e-09 6.270087000000e-06 3.128736000000e-09 6.270084000000e-06 3.478736000000e-09 6.270085000000e-06 3.828736000000e-09 6.270083000000e-06 4.076000000000e-09 6.270085000000e-06 4.076500000000e-09 2.038528000000e-02 4.077000000000e-09 4.008295000000e-02 4.077306000000e-09 3.906154000000e-02 4.077515000000e-09 3.826467000000e-02 4.078112000000e-09 3.572633000000e-02 4.079900000000e-09 2.851043000000e-02 4.082540000000e-09 1.954766000000e-02 4.086501000000e-09 1.039434000000e-02 4.092049000000e-09 3.780514000000e-03 4.100074000000e-09 6.746068000000e-04 4.112222000000e-09 -3.134189000000e-05 4.128358000000e-09 2.199917000000e-05 4.151784000000e-09 -4.196047000000e-06 4.181738000000e-09 1.635188000000e-05 4.223091000000e-09 -1.027996000000e-06 4.287381000000e-09 1.497498000000e-05 4.412795000000e-09 -6.574628000000e-07 4.639879000000e-09 1.494987000000e-05 4.989879000000e-09 -1.076129000000e-06 5.339879000000e-09 1.531123000000e-05 5.689879000000e-09 -1.377616000000e-06 6.039879000000e-09 1.560420000000e-05 6.389879000000e-09 -1.679127000000e-06 6.739879000000e-09 1.585969000000e-05 7.000000000000e-09 -1.969230000000e-06)
V_XOR_23 xor_23 0 PWL(0.000000000000e+00 6.995221000000e-06 1.000000000000e-12 6.997984000000e-06 2.000000000000e-12 7.000502000000e-06 5.200000000000e-12 7.006871000000e-06 1.544000000000e-11 7.014253000000e-06 4.820800000000e-11 7.014547000000e-06 1.530656000000e-10 7.014629000000e-06 4.886099000000e-10 7.014537000000e-06 8.386099000000e-10 7.014631000000e-06 9.995000000000e-10 7.014537000000e-06 9.996500000000e-10 7.014541000000e-06 1.000130000000e-09 7.014550000000e-06 1.000271000000e-09 7.014553000000e-06 1.000500000000e-09 7.014556000000e-06 1.000549000000e-09 7.014557000000e-06 1.000579000000e-09 7.014557000000e-06 1.000674000000e-09 7.014559000000e-06 1.000921000000e-09 7.014561000000e-06 1.001177000000e-09 7.014564000000e-06 1.001636000000e-09 7.014567000000e-06 1.002995000000e-09 7.014574000000e-06 1.004717000000e-09 7.014578000000e-06 1.007157000000e-09 7.014583000000e-06 1.009530000000e-09 7.014585000000e-06 1.012064000000e-09 7.014586000000e-06 1.014479000000e-09 7.014587000000e-06 1.016999000000e-09 7.014587000000e-06 1.019780000000e-09 7.014587000000e-06 1.023006000000e-09 7.014586000000e-06 1.025715000000e-09 7.014586000000e-06 1.028767000000e-09 7.014585000000e-06 1.031545000000e-09 7.014585000000e-06 1.034548000000e-09 7.014585000000e-06 1.037295000000e-09 7.014585000000e-06 1.040188000000e-09 7.014584000000e-06 1.042931000000e-09 7.014584000000e-06 1.046095000000e-09 7.014584000000e-06 1.049020000000e-09 7.014584000000e-06 1.051920000000e-09 7.014584000000e-06 1.055268000000e-09 7.014584000000e-06 1.057963000000e-09 7.014584000000e-06 1.059420000000e-09 7.014584000000e-06 1.060877000000e-09 7.014584000000e-06 1.063981000000e-09 7.014584000000e-06 1.066813000000e-09 7.014584000000e-06 1.069715000000e-09 7.014584000000e-06 1.073141000000e-09 7.014584000000e-06 1.075000000000e-09 7.014584000000e-06 1.075500000000e-09 -2.045888000000e-02 1.075834000000e-09 -3.391895000000e-02 1.076000000000e-09 -4.043047000000e-02 1.076266000000e-09 -3.910846000000e-02 1.076419000000e-09 -3.826786000000e-02 1.076822000000e-09 -3.580911000000e-02 1.078112000000e-09 -2.860478000000e-02 1.079915000000e-09 -2.077672000000e-02 1.082834000000e-09 -1.253812000000e-02 1.086452000000e-09 -6.732492000000e-03 1.089863000000e-09 -3.811583000000e-03 1.094093000000e-09 -1.921681000000e-03 1.097558000000e-09 -1.165445000000e-03 1.101264000000e-09 -7.065969000000e-04 1.105520000000e-09 -4.344228000000e-04 1.109056000000e-09 -2.959288000000e-04 1.112992000000e-09 -2.150839000000e-04 1.115807000000e-09 -1.673405000000e-04 1.118621000000e-09 -1.279798000000e-04 1.121942000000e-09 -1.058274000000e-04 1.125724000000e-09 -7.572437000000e-05 1.129501000000e-09 -6.325407000000e-05 1.133249000000e-09 -4.285626000000e-05 1.135809000000e-09 -3.587991000000e-05 1.138369000000e-09 -3.454717000000e-05 1.141791000000e-09 -2.268020000000e-05 1.145734000000e-09 -1.969639000000e-05 1.150017000000e-09 -1.008213000000e-05 1.153865000000e-09 -1.102566000000e-05 1.158361000000e-09 -4.749447000000e-06 1.161824000000e-09 -6.269400000000e-06 1.165535000000e-09 -1.363381000000e-06 1.169527000000e-09 -3.004000000000e-06 1.173109000000e-09 8.421522000000e-07 1.177056000000e-09 -9.417078000000e-07 1.179535000000e-09 1.080576000000e-07 1.182013000000e-09 2.831831000000e-06 1.185429000000e-09 9.489744000000e-07 1.189651000000e-09 3.474935000000e-06 1.193349000000e-09 2.230150000000e-06 1.197208000000e-09 4.177973000000e-06 1.200595000000e-09 2.903837000000e-06 1.204042000000e-09 4.370442000000e-06 1.207661000000e-09 3.378371000000e-06 1.212044000000e-09 4.811622000000e-06 1.215603000000e-09 3.987101000000e-06 1.219624000000e-09 5.079813000000e-06 1.222280000000e-09 5.068909000000e-06 1.224935000000e-09 4.475377000000e-06 1.228316000000e-09 5.352252000000e-06 1.229186000000e-09 5.237903000000e-06 1.230042000000e-09 5.195261000000e-06 1.232779000000e-09 6.109705000000e-06 1.235670000000e-09 6.042910000000e-06 1.238863000000e-09 6.018342000000e-06 1.243639000000e-09 5.931768000000e-06 1.246999000000e-09 5.993830000000e-06 1.250850000000e-09 5.921389000000e-06 1.255187000000e-09 5.993005000000e-06 1.258822000000e-09 5.926268000000e-06 1.259631000000e-09 5.957748000000e-06 1.260438000000e-09 5.962806000000e-06 1.263021000000e-09 5.962821000000e-06 1.265957000000e-09 5.965550000000e-06 1.269137000000e-09 5.963352000000e-06 1.273131000000e-09 5.966357000000e-06 1.276658000000e-09 5.964792000000e-06 1.280195000000e-09 5.967573000000e-06 1.284359000000e-09 5.966149000000e-06 1.288216000000e-09 5.968612000000e-06 1.291735000000e-09 5.967080000000e-06 1.292574000000e-09 5.968035000000e-06 1.293423000000e-09 5.968186000000e-06 1.296139000000e-09 5.968327000000e-06 1.299136000000e-09 5.968588000000e-06 1.302736000000e-09 5.968719000000e-06 1.306959000000e-09 5.968958000000e-06 1.310392000000e-09 5.969016000000e-06 1.314112000000e-09 5.969171000000e-06 1.317424000000e-09 5.969190000000e-06 1.320972000000e-09 5.969303000000e-06 1.324632000000e-09 5.969306000000e-06 1.327145000000e-09 5.969343000000e-06 1.329658000000e-09 5.969407000000e-06 1.333049000000e-09 5.969391000000e-06 1.337028000000e-09 5.969460000000e-06 1.341293000000e-09 5.969441000000e-06 1.345153000000e-09 5.969496000000e-06 1.349994000000e-09 5.969473000000e-06 1.353616000000e-09 5.969518000000e-06 1.357116000000e-09 5.969489000000e-06 1.357983000000e-09 5.969507000000e-06 1.358962000000e-09 5.969510000000e-06 1.362092000000e-09 5.969513000000e-06 1.364885000000e-09 5.969518000000e-06 1.369987000000e-09 5.969521000000e-06 1.373500000000e-09 5.969525000000e-06 1.377230000000e-09 5.969523000000e-06 1.381288000000e-09 5.969535000000e-06 1.384815000000e-09 5.969520000000e-06 1.388662000000e-09 5.969537000000e-06 1.389532000000e-09 5.969536000000e-06 1.390483000000e-09 5.969538000000e-06 1.393528000000e-09 5.969578000000e-06 1.396267000000e-09 5.969246000000e-06 1.399530000000e-09 5.969935000000e-06 1.403009000000e-09 5.969310000000e-06 1.406745000000e-09 5.969536000000e-06 1.410579000000e-09 5.969609000000e-06 1.413057000000e-09 5.970228000000e-06 1.415535000000e-09 5.971297000000e-06 1.418933000000e-09 5.962112000000e-06 1.419781000000e-09 5.966164000000e-06 1.420563000000e-09 5.969466000000e-06 1.423064000000e-09 5.971050000000e-06 1.426220000000e-09 5.970278000000e-06 1.429627000000e-09 5.967618000000e-06 1.432942000000e-09 5.987248000000e-06 1.436511000000e-09 6.299297000000e-06 1.439973000000e-09 5.591179000000e-06 1.444113000000e-09 5.764710000000e-06 1.447667000000e-09 5.778912000000e-06 1.448597000000e-09 5.713030000000e-06 1.449278000000e-09 5.730232000000e-06 1.451458000000e-09 5.751461000000e-06 1.454984000000e-09 7.719837000000e-06 1.458241000000e-09 1.182973000000e-05 1.461761000000e-09 2.671824000000e-05 1.465886000000e-09 -2.169324000000e-06 1.469389000000e-09 -4.376331000000e-05 1.472794000000e-09 -1.023946000000e-04 1.475276000000e-09 5.795534000000e-07 1.477758000000e-09 2.264149000000e-04 1.479095000000e-09 4.800592000000e-04 1.479882000000e-09 6.387919000000e-04 1.482402000000e-09 1.129303000000e-03 1.485321000000e-09 1.242033000000e-03 1.488790000000e-09 -1.683714000000e-03 1.492381000000e-09 -9.943100000000e-03 1.496661000000e-09 -2.201215000000e-02 1.500576000000e-09 -4.041700000000e-03 1.504103000000e-09 6.284210000000e-02 1.508121000000e-09 1.723469000000e-01 1.509046000000e-09 1.969024000000e-01 1.509764000000e-09 2.154686000000e-01 1.512062000000e-09 2.686089000000e-01 1.514727000000e-09 3.242127000000e-01 1.518391000000e-09 4.046475000000e-01 1.521668000000e-09 4.820947000000e-01 1.525243000000e-09 5.642303000000e-01 1.529365000000e-09 6.434001000000e-01 1.532875000000e-09 6.929487000000e-01 1.534025000000e-09 7.058489000000e-01 1.534117000000e-09 7.054431000000e-01 1.534180000000e-09 7.051959000000e-01 1.534382000000e-09 7.046914000000e-01 1.534737000000e-09 7.043148000000e-01 1.535025000000e-09 7.046121000000e-01 1.535086000000e-09 7.055726000000e-01 1.535120000000e-09 7.060996000000e-01 1.535227000000e-09 7.076716000000e-01 1.535516000000e-09 7.116059000000e-01 1.535770000000e-09 7.148568000000e-01 1.536253000000e-09 7.205468000000e-01 1.537797000000e-09 7.352334000000e-01 1.540037000000e-09 7.500133000000e-01 1.542991000000e-09 7.644856000000e-01 1.546340000000e-09 7.793962000000e-01 1.549563000000e-09 7.945247000000e-01 1.553023000000e-09 8.102060000000e-01 1.556674000000e-09 8.238094000000e-01 1.561332000000e-09 8.363321000000e-01 1.564959000000e-09 8.430607000000e-01 1.568637000000e-09 8.479438000000e-01 1.572862000000e-09 8.518688000000e-01 1.576410000000e-09 8.541473000000e-01 1.580380000000e-09 8.559608000000e-01 1.584817000000e-09 8.573271000000e-01 1.588226000000e-09 8.580557000000e-01 1.592181000000e-09 8.586495000000e-01 1.595925000000e-09 8.590482000000e-01 1.599741000000e-09 8.593266000000e-01 1.604581000000e-09 8.595717000000e-01 1.606342000000e-09 8.596345000000e-01 1.608103000000e-09 8.596833000000e-01 1.611836000000e-09 8.597785000000e-01 1.616035000000e-09 8.598421000000e-01 1.619218000000e-09 8.598822000000e-01 1.623182000000e-09 8.599103000000e-01 1.626358000000e-09 8.599358000000e-01 1.629985000000e-09 8.599475000000e-01 1.634074000000e-09 8.599606000000e-01 1.638238000000e-09 8.599664000000e-01 1.643068000000e-09 8.599769000000e-01 1.648476000000e-09 8.599772000000e-01 1.653917000000e-09 8.599842000000e-01 1.658595000000e-09 8.599816000000e-01 1.665047000000e-09 8.599869000000e-01 1.668427000000e-09 8.599832000000e-01 1.674362000000e-09 8.599875000000e-01 1.678501000000e-09 8.599840000000e-01 1.684581000000e-09 8.599880000000e-01 1.686093000000e-09 8.599866000000e-01 1.687486000000e-09 8.599864000000e-01 1.691945000000e-09 8.599872000000e-01 1.695547000000e-09 8.599872000000e-01 1.700342000000e-09 8.599875000000e-01 1.704014000000e-09 8.599875000000e-01 1.707642000000e-09 8.599876000000e-01 1.712914000000e-09 8.599876000000e-01 1.717024000000e-09 8.599877000000e-01 1.722796000000e-09 8.599877000000e-01 1.724262000000e-09 8.599877000000e-01 1.725743000000e-09 8.599877000000e-01 1.730482000000e-09 8.599877000000e-01 1.734128000000e-09 8.599877000000e-01 1.739613000000e-09 8.599877000000e-01 1.743241000000e-09 8.599877000000e-01 1.746998000000e-09 8.599877000000e-01 1.752400000000e-09 8.599877000000e-01 1.756586000000e-09 8.599877000000e-01 1.762468000000e-09 8.599877000000e-01 1.764025000000e-09 8.599877000000e-01 1.765380000000e-09 8.599877000000e-01 1.769719000000e-09 8.599877000000e-01 1.773264000000e-09 8.599877000000e-01 1.778028000000e-09 8.599877000000e-01 1.781718000000e-09 8.599877000000e-01 1.785310000000e-09 8.599877000000e-01 1.790811000000e-09 8.599877000000e-01 1.794844000000e-09 8.599877000000e-01 1.800637000000e-09 8.599877000000e-01 1.802097000000e-09 8.599877000000e-01 1.803580000000e-09 8.599877000000e-01 1.808326000000e-09 8.599877000000e-01 1.811970000000e-09 8.599877000000e-01 1.817496000000e-09 8.599877000000e-01 1.821120000000e-09 8.599877000000e-01 1.824884000000e-09 8.599877000000e-01 1.830308000000e-09 8.599877000000e-01 1.834495000000e-09 8.599877000000e-01 1.840377000000e-09 8.599877000000e-01 1.841939000000e-09 8.599877000000e-01 1.843284000000e-09 8.599877000000e-01 1.847586000000e-09 8.599877000000e-01 1.851115000000e-09 8.599877000000e-01 1.855851000000e-09 8.599877000000e-01 1.859543000000e-09 8.599877000000e-01 1.863125000000e-09 8.599877000000e-01 1.868621000000e-09 8.599877000000e-01 1.872640000000e-09 8.599877000000e-01 1.878406000000e-09 8.599877000000e-01 1.879857000000e-09 8.599877000000e-01 1.881342000000e-09 8.599877000000e-01 1.886097000000e-09 8.599877000000e-01 1.889729000000e-09 8.599878000000e-01 1.895406000000e-09 8.599877000000e-01 1.899019000000e-09 8.599877000000e-01 1.902802000000e-09 8.599881000000e-01 1.908327000000e-09 8.599882000000e-01 1.912510000000e-09 8.599876000000e-01 1.918396000000e-09 8.599868000000e-01 1.923452000000e-09 8.599848000000e-01 1.928319000000e-09 8.599831000000e-01 1.933832000000e-09 8.599822000000e-01 1.937865000000e-09 8.599789000000e-01 1.941516000000e-09 8.600108000000e-01 1.947123000000e-09 8.601196000000e-01 1.951206000000e-09 8.601419000000e-01 1.957151000000e-09 8.600762000000e-01 1.962202000000e-09 8.597021000000e-01 1.967100000000e-09 8.589253000000e-01 1.968013000000e-09 8.587600000000e-01 1.969099000000e-09 8.585518000000e-01 1.972453000000e-09 8.576312000000e-01 1.975701000000e-09 8.561620000000e-01 1.979195000000e-09 8.557016000000e-01 1.983866000000e-09 8.647606000000e-01 1.987814000000e-09 8.819891000000e-01 1.993099000000e-09 9.053792000000e-01 1.998488000000e-09 8.865761000000e-01 2.003935000000e-09 7.560512000000e-01 2.004866000000e-09 7.196069000000e-01 2.005730000000e-09 6.848003000000e-01 2.008495000000e-09 5.645027000000e-01 2.013208000000e-09 3.649806000000e-01 2.016501000000e-09 2.525138000000e-01 2.021215000000e-09 1.429826000000e-01 2.025252000000e-09 9.256685000000e-02 2.030301000000e-09 5.738390000000e-02 2.035760000000e-09 3.533651000000e-02 2.040977000000e-09 2.005384000000e-02 2.042009000000e-09 1.762289000000e-02 2.042812000000e-09 1.581320000000e-02 2.045379000000e-09 1.101758000000e-02 2.049639000000e-09 5.791838000000e-03 2.053254000000e-09 3.304218000000e-03 2.056728000000e-09 1.917984000000e-03 2.062152000000e-09 7.883888000000e-04 2.066039000000e-09 4.300749000000e-04 2.071558000000e-09 1.805440000000e-04 2.076872000000e-09 8.064187000000e-05 2.078300000000e-09 6.795333000000e-05 2.079144000000e-09 6.096944000000e-05 2.081843000000e-09 4.396796000000e-05 2.085459000000e-09 2.975464000000e-05 2.089564000000e-09 2.034825000000e-05 2.093109000000e-09 1.495186000000e-05 2.096789000000e-09 1.154570000000e-05 2.101106000000e-09 9.293629000000e-06 2.105378000000e-09 8.105939000000e-06 2.110838000000e-09 7.186453000000e-06 2.112251000000e-09 7.052126000000e-06 2.113753000000e-09 6.921889000000e-06 2.118558000000e-09 6.639715000000e-06 2.122133000000e-09 6.515946000000e-06 2.129360000000e-09 6.356741000000e-06 2.132821000000e-09 6.320124000000e-06 2.136929000000e-09 6.299702000000e-06 2.139763000000e-09 6.291055000000e-06 2.142597000000e-09 6.286854000000e-06 2.147012000000e-09 6.281620000000e-06 2.152765000000e-09 6.275197000000e-06 2.154377000000e-09 6.274014000000e-06 2.155442000000e-09 6.273284000000e-06 2.158852000000e-09 6.271483000000e-06 2.162621000000e-09 6.270163000000e-06 2.166944000000e-09 6.269315000000e-06 2.170618000000e-09 6.268919000000e-06 2.174167000000e-09 6.268690000000e-06 2.179170000000e-09 6.268374000000e-06 2.183292000000e-09 6.268163000000e-06 2.188867000000e-09 6.268005000000e-06 2.190278000000e-09 6.268004000000e-06 2.191779000000e-09 6.267989000000e-06 2.196584000000e-09 6.267953000000e-06 2.200169000000e-09 6.267936000000e-06 2.207050000000e-09 6.267925000000e-06 2.210543000000e-09 6.267909000000e-06 2.214570000000e-09 6.267906000000e-06 2.217383000000e-09 6.267903000000e-06 2.220196000000e-09 6.267901000000e-06 2.224548000000e-09 6.267901000000e-06 2.230327000000e-09 6.267900000000e-06 2.231668000000e-09 6.267902000000e-06 2.232487000000e-09 6.267897000000e-06 2.235108000000e-09 6.267899000000e-06 2.238430000000e-09 6.267898000000e-06 2.242101000000e-09 6.267898000000e-06 2.245250000000e-09 6.267898000000e-06 2.248623000000e-09 6.267897000000e-06 2.252399000000e-09 6.267897000000e-06 2.256336000000e-09 6.267897000000e-06 2.261919000000e-09 6.267896000000e-06 2.264384000000e-09 6.267898000000e-06 2.265883000000e-09 6.267897000000e-06 2.270679000000e-09 6.267892000000e-06 2.277378000000e-09 6.267898000000e-06 2.283984000000e-09 6.267895000000e-06 2.291963000000e-09 6.267895000000e-06 2.303337000000e-09 6.267894000000e-06 2.323042000000e-09 6.267894000000e-06 2.352076000000e-09 6.267892000000e-06 2.407975000000e-09 6.267891000000e-06 2.543499000000e-09 6.267888000000e-06 2.778736000000e-09 6.267886000000e-06 3.128736000000e-09 6.267885000000e-06 3.478736000000e-09 6.267885000000e-06 3.828736000000e-09 6.267885000000e-06 4.076000000000e-09 6.267885000000e-06 4.076500000000e-09 2.038340000000e-02 4.077000000000e-09 4.008101000000e-02 4.077306000000e-09 3.905960000000e-02 4.077515000000e-09 3.826274000000e-02 4.078112000000e-09 3.572447000000e-02 4.079900000000e-09 2.850894000000e-02 4.082540000000e-09 1.954672000000e-02 4.086501000000e-09 1.039390000000e-02 4.092049000000e-09 3.780369000000e-03 4.100074000000e-09 6.745838000000e-04 4.112222000000e-09 -3.133977000000e-05 4.128358000000e-09 2.199843000000e-05 4.151784000000e-09 -4.195740000000e-06 4.181738000000e-09 1.635174000000e-05 4.223091000000e-09 -1.028009000000e-06 4.287381000000e-09 1.497496000000e-05 4.412795000000e-09 -6.575455000000e-07 4.639879000000e-09 1.494987000000e-05 4.989879000000e-09 -1.076227000000e-06 5.339879000000e-09 1.531124000000e-05 5.689879000000e-09 -1.377723000000e-06 6.039879000000e-09 1.560422000000e-05 6.389879000000e-09 -1.679245000000e-06 6.739879000000e-09 1.585971000000e-05 7.000000000000e-09 -1.969359000000e-06)
V_XOR_24 xor_24 0 PWL(0.000000000000e+00 6.995221000000e-06 1.000000000000e-12 6.997984000000e-06 2.000000000000e-12 7.000502000000e-06 5.200000000000e-12 7.006871000000e-06 1.544000000000e-11 7.014253000000e-06 4.820800000000e-11 7.014547000000e-06 1.530656000000e-10 7.014629000000e-06 4.886099000000e-10 7.014537000000e-06 8.386099000000e-10 7.014631000000e-06 9.995000000000e-10 7.014537000000e-06 9.996500000000e-10 7.014541000000e-06 1.000130000000e-09 7.014550000000e-06 1.000271000000e-09 7.014553000000e-06 1.000500000000e-09 7.014556000000e-06 1.000549000000e-09 7.014557000000e-06 1.000579000000e-09 7.014557000000e-06 1.000674000000e-09 7.014559000000e-06 1.000921000000e-09 7.014561000000e-06 1.001177000000e-09 7.014564000000e-06 1.001636000000e-09 7.014567000000e-06 1.002995000000e-09 7.014574000000e-06 1.004717000000e-09 7.014578000000e-06 1.007157000000e-09 7.014583000000e-06 1.009530000000e-09 7.014585000000e-06 1.012064000000e-09 7.014586000000e-06 1.014479000000e-09 7.014587000000e-06 1.016999000000e-09 7.014587000000e-06 1.019780000000e-09 7.014587000000e-06 1.023006000000e-09 7.014586000000e-06 1.025715000000e-09 7.014586000000e-06 1.028767000000e-09 7.014585000000e-06 1.031545000000e-09 7.014585000000e-06 1.034548000000e-09 7.014585000000e-06 1.037295000000e-09 7.014585000000e-06 1.040188000000e-09 7.014584000000e-06 1.042931000000e-09 7.014584000000e-06 1.046095000000e-09 7.014584000000e-06 1.049020000000e-09 7.014584000000e-06 1.051920000000e-09 7.014584000000e-06 1.055268000000e-09 7.014584000000e-06 1.057963000000e-09 7.014584000000e-06 1.059420000000e-09 7.014584000000e-06 1.060877000000e-09 7.014584000000e-06 1.063981000000e-09 7.014584000000e-06 1.066813000000e-09 7.014584000000e-06 1.069715000000e-09 7.014584000000e-06 1.073141000000e-09 7.014584000000e-06 1.075000000000e-09 7.014584000000e-06 1.075500000000e-09 -2.045888000000e-02 1.075834000000e-09 -3.391895000000e-02 1.076000000000e-09 -4.043047000000e-02 1.076266000000e-09 -3.910846000000e-02 1.076419000000e-09 -3.826786000000e-02 1.076822000000e-09 -3.580911000000e-02 1.078112000000e-09 -2.860478000000e-02 1.079915000000e-09 -2.077672000000e-02 1.082834000000e-09 -1.253812000000e-02 1.086452000000e-09 -6.732492000000e-03 1.089863000000e-09 -3.811583000000e-03 1.094093000000e-09 -1.921681000000e-03 1.097558000000e-09 -1.165445000000e-03 1.101264000000e-09 -7.065969000000e-04 1.105520000000e-09 -4.344228000000e-04 1.109056000000e-09 -2.959288000000e-04 1.112992000000e-09 -2.150839000000e-04 1.115807000000e-09 -1.673405000000e-04 1.118621000000e-09 -1.279798000000e-04 1.121942000000e-09 -1.058274000000e-04 1.125724000000e-09 -7.572437000000e-05 1.129501000000e-09 -6.325407000000e-05 1.133249000000e-09 -4.285626000000e-05 1.135809000000e-09 -3.587991000000e-05 1.138369000000e-09 -3.454717000000e-05 1.141791000000e-09 -2.268020000000e-05 1.145734000000e-09 -1.969639000000e-05 1.150017000000e-09 -1.008213000000e-05 1.153865000000e-09 -1.102566000000e-05 1.158361000000e-09 -4.749447000000e-06 1.161824000000e-09 -6.269400000000e-06 1.165535000000e-09 -1.363381000000e-06 1.169527000000e-09 -3.004000000000e-06 1.173109000000e-09 8.421522000000e-07 1.177056000000e-09 -9.417078000000e-07 1.179535000000e-09 1.080576000000e-07 1.182013000000e-09 2.831831000000e-06 1.185429000000e-09 9.489744000000e-07 1.189651000000e-09 3.474935000000e-06 1.193349000000e-09 2.230150000000e-06 1.197208000000e-09 4.177973000000e-06 1.200595000000e-09 2.903837000000e-06 1.204042000000e-09 4.370442000000e-06 1.207661000000e-09 3.378371000000e-06 1.212044000000e-09 4.811622000000e-06 1.215603000000e-09 3.987101000000e-06 1.219624000000e-09 5.079813000000e-06 1.222280000000e-09 5.068909000000e-06 1.224935000000e-09 4.475377000000e-06 1.228316000000e-09 5.352252000000e-06 1.229186000000e-09 5.237903000000e-06 1.230042000000e-09 5.195261000000e-06 1.232779000000e-09 6.109705000000e-06 1.235670000000e-09 6.042910000000e-06 1.238863000000e-09 6.018342000000e-06 1.243639000000e-09 5.931768000000e-06 1.246999000000e-09 5.993830000000e-06 1.250850000000e-09 5.921389000000e-06 1.255187000000e-09 5.993005000000e-06 1.258822000000e-09 5.926268000000e-06 1.259631000000e-09 5.957748000000e-06 1.260438000000e-09 5.962806000000e-06 1.263021000000e-09 5.962821000000e-06 1.265957000000e-09 5.965550000000e-06 1.269137000000e-09 5.963352000000e-06 1.273131000000e-09 5.966357000000e-06 1.276658000000e-09 5.964792000000e-06 1.280195000000e-09 5.967573000000e-06 1.284359000000e-09 5.966149000000e-06 1.288216000000e-09 5.968612000000e-06 1.291735000000e-09 5.967080000000e-06 1.292574000000e-09 5.968035000000e-06 1.293423000000e-09 5.968186000000e-06 1.296139000000e-09 5.968327000000e-06 1.299136000000e-09 5.968588000000e-06 1.302736000000e-09 5.968719000000e-06 1.306959000000e-09 5.968958000000e-06 1.310392000000e-09 5.969016000000e-06 1.314112000000e-09 5.969171000000e-06 1.317424000000e-09 5.969190000000e-06 1.320972000000e-09 5.969303000000e-06 1.324632000000e-09 5.969306000000e-06 1.327145000000e-09 5.969343000000e-06 1.329658000000e-09 5.969407000000e-06 1.333049000000e-09 5.969391000000e-06 1.337028000000e-09 5.969460000000e-06 1.341293000000e-09 5.969441000000e-06 1.345153000000e-09 5.969496000000e-06 1.349994000000e-09 5.969473000000e-06 1.353616000000e-09 5.969518000000e-06 1.357116000000e-09 5.969489000000e-06 1.357983000000e-09 5.969507000000e-06 1.358962000000e-09 5.969510000000e-06 1.362092000000e-09 5.969513000000e-06 1.364885000000e-09 5.969518000000e-06 1.369987000000e-09 5.969521000000e-06 1.373500000000e-09 5.969525000000e-06 1.377230000000e-09 5.969526000000e-06 1.381288000000e-09 5.969529000000e-06 1.384815000000e-09 5.969529000000e-06 1.388662000000e-09 5.969531000000e-06 1.389532000000e-09 5.969531000000e-06 1.390483000000e-09 5.969531000000e-06 1.393528000000e-09 5.969532000000e-06 1.396267000000e-09 5.969527000000e-06 1.399530000000e-09 5.969543000000e-06 1.403009000000e-09 5.969522000000e-06 1.406745000000e-09 5.969539000000e-06 1.410579000000e-09 5.969533000000e-06 1.413057000000e-09 5.969537000000e-06 1.415535000000e-09 5.969546000000e-06 1.418933000000e-09 5.969420000000e-06 1.419781000000e-09 5.969554000000e-06 1.420563000000e-09 5.969635000000e-06 1.423064000000e-09 5.969551000000e-06 1.426220000000e-09 5.969506000000e-06 1.429627000000e-09 5.969508000000e-06 1.432942000000e-09 5.969761000000e-06 1.436511000000e-09 5.972656000000e-06 1.439973000000e-09 5.957333000000e-06 1.444113000000e-09 5.979222000000e-06 1.447667000000e-09 5.968910000000e-06 1.448597000000e-09 5.967888000000e-06 1.449278000000e-09 5.968805000000e-06 1.451458000000e-09 5.969147000000e-06 1.454984000000e-09 5.989789000000e-06 1.458241000000e-09 6.326583000000e-06 1.461761000000e-09 5.555938000000e-06 1.465886000000e-09 5.737130000000e-06 1.469389000000e-09 5.792490000000e-06 1.472794000000e-09 5.660777000000e-06 1.475276000000e-09 6.899604000000e-06 1.477758000000e-09 9.263948000000e-06 1.479095000000e-09 1.046120000000e-05 1.479882000000e-09 1.098928000000e-05 1.482402000000e-09 2.680209000000e-05 1.485321000000e-09 1.267025000000e-05 1.488790000000e-09 -2.176226000000e-05 1.492381000000e-09 -8.307587000000e-05 1.496661000000e-09 -2.213823000000e-05 1.500576000000e-09 5.239175000000e-04 1.504103000000e-09 1.269846000000e-03 1.508121000000e-09 4.645436000000e-04 1.509046000000e-09 -4.650866000000e-04 1.509764000000e-09 -1.334691000000e-03 1.512062000000e-09 -5.722538000000e-03 1.514727000000e-09 -1.341958000000e-02 1.518391000000e-09 -2.222548000000e-02 1.521668000000e-09 -6.081951000000e-03 1.525243000000e-09 6.099277000000e-02 1.529365000000e-09 1.731356000000e-01 1.532875000000e-09 2.603508000000e-01 1.534025000000e-09 2.845477000000e-01 1.534117000000e-09 2.850008000000e-01 1.534180000000e-09 2.853237000000e-01 1.534382000000e-09 2.864784000000e-01 1.534737000000e-09 2.888603000000e-01 1.535025000000e-09 2.915996000000e-01 1.535086000000e-09 2.931147000000e-01 1.535120000000e-09 2.939491000000e-01 1.535227000000e-09 2.965854000000e-01 1.535516000000e-09 3.036686000000e-01 1.535770000000e-09 3.098415000000e-01 1.536253000000e-09 3.215076000000e-01 1.537797000000e-09 3.588539000000e-01 1.540037000000e-09 4.138361000000e-01 1.542991000000e-09 4.867060000000e-01 1.546340000000e-09 5.643818000000e-01 1.549563000000e-09 6.264367000000e-01 1.553023000000e-09 6.752778000000e-01 1.556674000000e-09 7.112535000000e-01 1.561332000000e-09 7.442092000000e-01 1.564959000000e-09 7.652525000000e-01 1.568637000000e-09 7.861505000000e-01 1.572862000000e-09 8.078761000000e-01 1.576410000000e-09 8.220882000000e-01 1.580380000000e-09 8.336477000000e-01 1.584817000000e-09 8.425262000000e-01 1.588226000000e-09 8.472515000000e-01 1.592181000000e-09 8.511723000000e-01 1.595925000000e-09 8.537667000000e-01 1.599741000000e-09 8.556293000000e-01 1.604581000000e-09 8.572227000000e-01 1.606342000000e-09 8.576502000000e-01 1.608103000000e-09 8.579966000000e-01 1.611836000000e-09 8.585836000000e-01 1.616035000000e-09 8.590396000000e-01 1.619218000000e-09 8.592836000000e-01 1.623182000000e-09 8.595010000000e-01 1.626358000000e-09 8.596265000000e-01 1.629985000000e-09 8.597290000000e-01 1.634074000000e-09 8.598123000000e-01 1.638238000000e-09 8.598678000000e-01 1.643068000000e-09 8.599120000000e-01 1.648476000000e-09 8.599411000000e-01 1.653917000000e-09 8.599603000000e-01 1.658595000000e-09 8.599688000000e-01 1.665047000000e-09 8.599779000000e-01 1.668427000000e-09 8.599794000000e-01 1.674362000000e-09 8.599833000000e-01 1.678501000000e-09 8.599836000000e-01 1.684581000000e-09 8.599858000000e-01 1.686093000000e-09 8.599856000000e-01 1.687486000000e-09 8.599859000000e-01 1.691945000000e-09 8.599864000000e-01 1.695547000000e-09 8.599866000000e-01 1.700342000000e-09 8.599869000000e-01 1.704014000000e-09 8.599870000000e-01 1.707642000000e-09 8.599871000000e-01 1.712914000000e-09 8.599872000000e-01 1.717024000000e-09 8.599872000000e-01 1.722796000000e-09 8.599873000000e-01 1.724262000000e-09 8.599873000000e-01 1.725743000000e-09 8.599873000000e-01 1.730482000000e-09 8.599873000000e-01 1.734128000000e-09 8.599873000000e-01 1.739613000000e-09 8.599873000000e-01 1.743241000000e-09 8.599873000000e-01 1.746998000000e-09 8.599873000000e-01 1.752400000000e-09 8.599873000000e-01 1.756586000000e-09 8.599873000000e-01 1.762468000000e-09 8.599873000000e-01 1.764025000000e-09 8.599873000000e-01 1.765380000000e-09 8.599873000000e-01 1.769719000000e-09 8.599873000000e-01 1.773264000000e-09 8.599873000000e-01 1.778028000000e-09 8.599873000000e-01 1.781718000000e-09 8.599873000000e-01 1.785310000000e-09 8.599873000000e-01 1.790811000000e-09 8.599873000000e-01 1.794844000000e-09 8.599873000000e-01 1.800637000000e-09 8.599873000000e-01 1.802097000000e-09 8.599873000000e-01 1.803580000000e-09 8.599873000000e-01 1.808326000000e-09 8.599873000000e-01 1.811970000000e-09 8.599873000000e-01 1.817496000000e-09 8.599873000000e-01 1.821120000000e-09 8.599873000000e-01 1.824884000000e-09 8.599873000000e-01 1.830308000000e-09 8.599873000000e-01 1.834495000000e-09 8.599873000000e-01 1.840377000000e-09 8.599873000000e-01 1.841939000000e-09 8.599873000000e-01 1.843284000000e-09 8.599873000000e-01 1.847586000000e-09 8.599873000000e-01 1.851115000000e-09 8.599873000000e-01 1.855851000000e-09 8.599873000000e-01 1.859543000000e-09 8.599873000000e-01 1.863125000000e-09 8.599873000000e-01 1.868621000000e-09 8.599873000000e-01 1.872640000000e-09 8.599873000000e-01 1.878406000000e-09 8.599873000000e-01 1.879857000000e-09 8.599873000000e-01 1.881342000000e-09 8.599873000000e-01 1.886097000000e-09 8.599873000000e-01 1.889729000000e-09 8.599873000000e-01 1.895406000000e-09 8.599873000000e-01 1.899019000000e-09 8.599873000000e-01 1.902802000000e-09 8.599873000000e-01 1.908327000000e-09 8.599873000000e-01 1.912510000000e-09 8.599873000000e-01 1.918396000000e-09 8.599873000000e-01 1.923452000000e-09 8.599873000000e-01 1.928319000000e-09 8.599873000000e-01 1.933832000000e-09 8.599873000000e-01 1.937865000000e-09 8.599873000000e-01 1.941516000000e-09 8.599877000000e-01 1.947123000000e-09 8.599878000000e-01 1.951206000000e-09 8.599872000000e-01 1.957151000000e-09 8.599864000000e-01 1.962202000000e-09 8.599844000000e-01 1.967100000000e-09 8.599827000000e-01 1.968013000000e-09 8.599831000000e-01 1.969099000000e-09 8.599833000000e-01 1.972453000000e-09 8.599816000000e-01 1.975701000000e-09 8.599772000000e-01 1.979195000000e-09 8.599939000000e-01 1.983866000000e-09 8.600795000000e-01 1.987814000000e-09 8.601340000000e-01 1.993099000000e-09 8.601298000000e-01 1.998488000000e-09 8.599369000000e-01 2.003935000000e-09 8.592805000000e-01 2.004866000000e-09 8.591187000000e-01 2.005730000000e-09 8.589671000000e-01 2.008495000000e-09 8.584156000000e-01 2.013208000000e-09 8.567682000000e-01 2.016501000000e-09 8.554186000000e-01 2.021215000000e-09 8.606073000000e-01 2.025252000000e-09 8.755946000000e-01 2.030301000000e-09 8.995529000000e-01 2.035760000000e-09 9.003172000000e-01 2.040977000000e-09 8.116224000000e-01 2.042009000000e-09 7.768436000000e-01 2.042812000000e-09 7.485219000000e-01 2.045379000000e-09 6.464343000000e-01 2.049639000000e-09 4.589872000000e-01 2.053254000000e-09 3.170808000000e-01 2.056728000000e-09 2.114294000000e-01 2.062152000000e-09 1.116701000000e-01 2.066039000000e-09 7.608921000000e-02 2.071558000000e-09 4.599066000000e-02 2.076872000000e-09 2.816149000000e-02 2.078300000000e-09 2.412667000000e-02 2.079144000000e-09 2.182358000000e-02 2.081843000000e-09 1.544203000000e-02 2.085459000000e-09 9.239231000000e-03 2.089564000000e-09 4.939423000000e-03 2.093109000000e-09 2.848445000000e-03 2.096789000000e-09 1.595147000000e-03 2.101106000000e-09 7.998934000000e-04 2.105378000000e-09 4.097372000000e-04 2.110838000000e-09 1.736912000000e-04 2.112251000000e-09 1.443340000000e-04 2.113753000000e-09 1.163505000000e-04 2.118558000000e-09 5.914834000000e-05 2.122133000000e-09 3.867354000000e-05 2.129360000000e-09 1.783731000000e-05 2.132821000000e-09 1.357717000000e-05 2.136929000000e-09 1.045662000000e-05 2.139763000000e-09 9.078713000000e-06 2.142597000000e-09 8.333716000000e-06 2.147012000000e-09 7.386704000000e-06 2.152765000000e-09 6.876373000000e-06 2.154377000000e-09 6.779119000000e-06 2.155442000000e-09 6.722190000000e-06 2.158852000000e-09 6.577652000000e-06 2.162621000000e-09 6.462706000000e-06 2.166944000000e-09 6.373246000000e-06 2.170618000000e-09 6.326842000000e-06 2.174167000000e-09 6.304476000000e-06 2.179170000000e-09 6.289394000000e-06 2.183292000000e-09 6.281745000000e-06 2.188867000000e-09 6.272574000000e-06 2.190278000000e-09 6.271712000000e-06 2.191779000000e-09 6.270762000000e-06 2.196584000000e-09 6.268448000000e-06 2.200169000000e-09 6.267130000000e-06 2.207050000000e-09 6.265605000000e-06 2.210543000000e-09 6.265301000000e-06 2.214570000000e-09 6.265105000000e-06 2.217383000000e-09 6.264948000000e-06 2.220196000000e-09 6.264774000000e-06 2.224548000000e-09 6.264625000000e-06 2.230327000000e-09 6.264496000000e-06 2.231668000000e-09 6.264495000000e-06 2.232487000000e-09 6.264488000000e-06 2.235108000000e-09 6.264480000000e-06 2.238430000000e-09 6.264469000000e-06 2.242101000000e-09 6.264460000000e-06 2.245250000000e-09 6.264453000000e-06 2.248623000000e-09 6.264447000000e-06 2.252399000000e-09 6.264443000000e-06 2.256336000000e-09 6.264437000000e-06 2.261919000000e-09 6.264436000000e-06 2.264384000000e-09 6.264437000000e-06 2.265883000000e-09 6.264436000000e-06 2.270679000000e-09 6.264430000000e-06 2.277378000000e-09 6.264432000000e-06 2.283984000000e-09 6.264434000000e-06 2.291963000000e-09 6.264432000000e-06 2.303337000000e-09 6.264430000000e-06 2.323042000000e-09 6.264430000000e-06 2.352076000000e-09 6.264429000000e-06 2.407975000000e-09 6.264426000000e-06 2.543499000000e-09 6.264426000000e-06 2.778736000000e-09 6.264421000000e-06 3.128736000000e-09 6.264423000000e-06 3.478736000000e-09 6.264419000000e-06 3.828736000000e-09 6.264423000000e-06 4.076000000000e-09 6.264420000000e-06 4.076500000000e-09 2.038341000000e-02 4.077000000000e-09 4.008093000000e-02 4.077306000000e-09 3.905949000000e-02 4.077515000000e-09 3.826261000000e-02 4.078112000000e-09 3.572428000000e-02 4.079900000000e-09 2.850870000000e-02 4.082540000000e-09 1.954652000000e-02 4.086501000000e-09 1.039378000000e-02 4.092049000000e-09 3.780328000000e-03 4.100074000000e-09 6.745773000000e-04 4.112222000000e-09 -3.133943000000e-05 4.128358000000e-09 2.199836000000e-05 4.151784000000e-09 -4.195700000000e-06 4.181738000000e-09 1.635173000000e-05 4.223091000000e-09 -1.027985000000e-06 4.287381000000e-09 1.497496000000e-05 4.412795000000e-09 -6.575224000000e-07 4.639879000000e-09 1.494988000000e-05 4.989879000000e-09 -1.076205000000e-06 5.339879000000e-09 1.531126000000e-05 5.689879000000e-09 -1.377704000000e-06 6.039879000000e-09 1.560424000000e-05 6.389879000000e-09 -1.679228000000e-06 6.739879000000e-09 1.585973000000e-05 7.000000000000e-09 -1.969343000000e-06)
V_XOR_25 xor_25 0 PWL(0.000000000000e+00 6.995221000000e-06 1.000000000000e-12 6.997984000000e-06 2.000000000000e-12 7.000502000000e-06 5.200000000000e-12 7.006871000000e-06 1.544000000000e-11 7.014253000000e-06 4.820800000000e-11 7.014547000000e-06 1.530656000000e-10 7.014629000000e-06 4.886099000000e-10 7.014537000000e-06 8.386099000000e-10 7.014631000000e-06 9.995000000000e-10 7.014537000000e-06 9.996500000000e-10 7.014541000000e-06 1.000130000000e-09 7.014550000000e-06 1.000271000000e-09 7.014553000000e-06 1.000500000000e-09 7.014556000000e-06 1.000549000000e-09 7.014557000000e-06 1.000579000000e-09 7.014557000000e-06 1.000674000000e-09 7.014559000000e-06 1.000921000000e-09 7.014561000000e-06 1.001177000000e-09 7.014564000000e-06 1.001636000000e-09 7.014567000000e-06 1.002995000000e-09 7.014574000000e-06 1.004717000000e-09 7.014578000000e-06 1.007157000000e-09 7.014583000000e-06 1.009530000000e-09 7.014585000000e-06 1.012064000000e-09 7.014586000000e-06 1.014479000000e-09 7.014587000000e-06 1.016999000000e-09 7.014587000000e-06 1.019780000000e-09 7.014587000000e-06 1.023006000000e-09 7.014586000000e-06 1.025715000000e-09 7.014586000000e-06 1.028767000000e-09 7.014585000000e-06 1.031545000000e-09 7.014585000000e-06 1.034548000000e-09 7.014585000000e-06 1.037295000000e-09 7.014585000000e-06 1.040188000000e-09 7.014584000000e-06 1.042931000000e-09 7.014584000000e-06 1.046095000000e-09 7.014584000000e-06 1.049020000000e-09 7.014584000000e-06 1.051920000000e-09 7.014584000000e-06 1.055268000000e-09 7.014584000000e-06 1.057963000000e-09 7.014584000000e-06 1.059420000000e-09 7.014584000000e-06 1.060877000000e-09 7.014584000000e-06 1.063981000000e-09 7.014584000000e-06 1.066813000000e-09 7.014584000000e-06 1.069715000000e-09 7.014584000000e-06 1.073141000000e-09 7.014584000000e-06 1.075000000000e-09 7.014584000000e-06 1.075500000000e-09 -2.045888000000e-02 1.075834000000e-09 -3.391895000000e-02 1.076000000000e-09 -4.043047000000e-02 1.076266000000e-09 -3.910846000000e-02 1.076419000000e-09 -3.826786000000e-02 1.076822000000e-09 -3.580911000000e-02 1.078112000000e-09 -2.860478000000e-02 1.079915000000e-09 -2.077672000000e-02 1.082834000000e-09 -1.253812000000e-02 1.086452000000e-09 -6.732492000000e-03 1.089863000000e-09 -3.811583000000e-03 1.094093000000e-09 -1.921680000000e-03 1.097558000000e-09 -1.165445000000e-03 1.101264000000e-09 -7.065969000000e-04 1.105520000000e-09 -4.344228000000e-04 1.109056000000e-09 -2.959288000000e-04 1.112992000000e-09 -2.150839000000e-04 1.115807000000e-09 -1.673405000000e-04 1.118621000000e-09 -1.279798000000e-04 1.121942000000e-09 -1.058274000000e-04 1.125724000000e-09 -7.572437000000e-05 1.129501000000e-09 -6.325407000000e-05 1.133249000000e-09 -4.285625000000e-05 1.135809000000e-09 -3.587991000000e-05 1.138369000000e-09 -3.454717000000e-05 1.141791000000e-09 -2.268020000000e-05 1.145734000000e-09 -1.969638000000e-05 1.150017000000e-09 -1.008214000000e-05 1.153865000000e-09 -1.102566000000e-05 1.158361000000e-09 -4.749447000000e-06 1.161824000000e-09 -6.269400000000e-06 1.165535000000e-09 -1.363381000000e-06 1.169527000000e-09 -3.004000000000e-06 1.173109000000e-09 8.421522000000e-07 1.177056000000e-09 -9.417079000000e-07 1.179535000000e-09 1.080575000000e-07 1.182013000000e-09 2.831831000000e-06 1.185429000000e-09 9.489743000000e-07 1.189651000000e-09 3.474935000000e-06 1.193349000000e-09 2.230150000000e-06 1.197208000000e-09 4.177973000000e-06 1.200595000000e-09 2.903837000000e-06 1.204042000000e-09 4.370442000000e-06 1.207661000000e-09 3.378371000000e-06 1.212044000000e-09 4.811622000000e-06 1.215603000000e-09 3.987101000000e-06 1.219624000000e-09 5.079813000000e-06 1.222280000000e-09 5.068909000000e-06 1.224935000000e-09 4.475377000000e-06 1.228316000000e-09 5.352252000000e-06 1.229186000000e-09 5.237903000000e-06 1.230042000000e-09 5.195261000000e-06 1.232779000000e-09 6.109705000000e-06 1.235670000000e-09 6.042910000000e-06 1.238863000000e-09 6.018342000000e-06 1.243639000000e-09 5.931768000000e-06 1.246999000000e-09 5.993830000000e-06 1.250850000000e-09 5.921389000000e-06 1.255187000000e-09 5.993005000000e-06 1.258822000000e-09 5.926268000000e-06 1.259631000000e-09 5.957748000000e-06 1.260438000000e-09 5.962806000000e-06 1.263021000000e-09 5.962821000000e-06 1.265957000000e-09 5.965549000000e-06 1.269137000000e-09 5.963352000000e-06 1.273131000000e-09 5.966357000000e-06 1.276658000000e-09 5.964792000000e-06 1.280195000000e-09 5.967573000000e-06 1.284359000000e-09 5.966149000000e-06 1.288216000000e-09 5.968612000000e-06 1.291735000000e-09 5.967080000000e-06 1.292574000000e-09 5.968035000000e-06 1.293423000000e-09 5.968185000000e-06 1.296139000000e-09 5.968327000000e-06 1.299136000000e-09 5.968587000000e-06 1.302736000000e-09 5.968719000000e-06 1.306959000000e-09 5.968958000000e-06 1.310392000000e-09 5.969015000000e-06 1.314112000000e-09 5.969171000000e-06 1.317424000000e-09 5.969190000000e-06 1.320972000000e-09 5.969303000000e-06 1.324632000000e-09 5.969306000000e-06 1.327145000000e-09 5.969343000000e-06 1.329658000000e-09 5.969407000000e-06 1.333049000000e-09 5.969391000000e-06 1.337028000000e-09 5.969460000000e-06 1.341293000000e-09 5.969441000000e-06 1.345153000000e-09 5.969496000000e-06 1.349994000000e-09 5.969472000000e-06 1.353616000000e-09 5.969518000000e-06 1.357116000000e-09 5.969489000000e-06 1.357983000000e-09 5.969507000000e-06 1.358962000000e-09 5.969510000000e-06 1.362092000000e-09 5.969513000000e-06 1.364885000000e-09 5.969518000000e-06 1.369987000000e-09 5.969521000000e-06 1.373500000000e-09 5.969525000000e-06 1.377230000000e-09 5.969526000000e-06 1.381288000000e-09 5.969528000000e-06 1.384815000000e-09 5.969529000000e-06 1.388662000000e-09 5.969531000000e-06 1.389532000000e-09 5.969530000000e-06 1.390483000000e-09 5.969531000000e-06 1.393528000000e-09 5.969531000000e-06 1.396267000000e-09 5.969532000000e-06 1.399530000000e-09 5.969532000000e-06 1.403009000000e-09 5.969532000000e-06 1.406745000000e-09 5.969533000000e-06 1.410579000000e-09 5.969533000000e-06 1.413057000000e-09 5.969533000000e-06 1.415535000000e-09 5.969534000000e-06 1.418933000000e-09 5.969532000000e-06 1.419781000000e-09 5.969535000000e-06 1.420563000000e-09 5.969536000000e-06 1.423064000000e-09 5.969532000000e-06 1.426220000000e-09 5.969533000000e-06 1.429627000000e-09 5.969534000000e-06 1.432942000000e-09 5.969537000000e-06 1.436511000000e-09 5.969564000000e-06 1.439973000000e-09 5.969338000000e-06 1.444113000000e-09 5.969865000000e-06 1.447667000000e-09 5.969290000000e-06 1.448597000000e-09 5.969378000000e-06 1.449278000000e-09 5.969468000000e-06 1.451458000000e-09 5.969536000000e-06 1.454984000000e-09 5.969765000000e-06 1.458241000000e-09 5.973355000000e-06 1.461761000000e-09 5.956136000000e-06 1.465886000000e-09 5.980423000000e-06 1.469389000000e-09 5.969680000000e-06 1.472794000000e-09 5.967376000000e-06 1.475276000000e-09 5.977612000000e-06 1.477758000000e-09 5.997895000000e-06 1.479095000000e-09 6.379853000000e-06 1.479882000000e-09 6.035324000000e-06 1.482402000000e-09 5.482966000000e-06 1.485321000000e-09 5.710441000000e-06 1.488790000000e-09 5.770815000000e-06 1.492381000000e-09 5.621251000000e-06 1.496661000000e-09 7.010301000000e-06 1.500576000000e-09 1.146839000000e-05 1.504103000000e-09 2.731107000000e-05 1.508121000000e-09 -1.215447000000e-06 1.509046000000e-09 -1.355001000000e-05 1.509764000000e-09 -8.978594000000e-06 1.512062000000e-09 -5.732006000000e-05 1.514727000000e-09 -9.430254000000e-05 1.518391000000e-09 1.659711000000e-05 1.521668000000e-09 5.326064000000e-04 1.525243000000e-09 1.273730000000e-03 1.529365000000e-09 3.966692000000e-04 1.532875000000e-09 -4.728267000000e-03 1.534025000000e-09 -7.612221000000e-03 1.534117000000e-09 -9.125012000000e-03 1.534180000000e-09 -1.014479000000e-02 1.534382000000e-09 -1.315349000000e-02 1.534737000000e-09 -1.789088000000e-02 1.535025000000e-09 -2.098936000000e-02 1.535086000000e-09 -2.073200000000e-02 1.535120000000e-09 -2.058179000000e-02 1.535227000000e-09 -2.014808000000e-02 1.535516000000e-09 -1.942157000000e-02 1.535770000000e-09 -1.905704000000e-02 1.536253000000e-09 -1.885642000000e-02 1.537797000000e-09 -2.063443000000e-02 1.540037000000e-09 -2.237038000000e-02 1.542991000000e-09 -3.381429000000e-03 1.546340000000e-09 6.116708000000e-02 1.549563000000e-09 1.495625000000e-01 1.553023000000e-09 2.392874000000e-01 1.556674000000e-09 3.184343000000e-01 1.561332000000e-09 4.206276000000e-01 1.564959000000e-09 5.065113000000e-01 1.568637000000e-09 5.866611000000e-01 1.572862000000e-09 6.570236000000e-01 1.576410000000e-09 6.971809000000e-01 1.580380000000e-09 7.292923000000e-01 1.584817000000e-09 7.568467000000e-01 1.588226000000e-09 7.762549000000e-01 1.592181000000e-09 7.980332000000e-01 1.595925000000e-09 8.152947000000e-01 1.599741000000e-09 8.283908000000e-01 1.604581000000e-09 8.398062000000e-01 1.606342000000e-09 8.428944000000e-01 1.608103000000e-09 8.454146000000e-01 1.611836000000e-09 8.496856000000e-01 1.616035000000e-09 8.530221000000e-01 1.619218000000e-09 8.548077000000e-01 1.623182000000e-09 8.564079000000e-01 1.626358000000e-09 8.573276000000e-01 1.629985000000e-09 8.580884000000e-01 1.634074000000e-09 8.586960000000e-01 1.638238000000e-09 8.591095000000e-01 1.643068000000e-09 8.594339000000e-01 1.648476000000e-09 8.596517000000e-01 1.653917000000e-09 8.597889000000e-01 1.658595000000e-09 8.598580000000e-01 1.665047000000e-09 8.599180000000e-01 1.668427000000e-09 8.599355000000e-01 1.674362000000e-09 8.599611000000e-01 1.678501000000e-09 8.599652000000e-01 1.684581000000e-09 8.599770000000e-01 1.686093000000e-09 8.599772000000e-01 1.687486000000e-09 8.599784000000e-01 1.691945000000e-09 8.599816000000e-01 1.695547000000e-09 8.599832000000e-01 1.700342000000e-09 8.599847000000e-01 1.704014000000e-09 8.599854000000e-01 1.707642000000e-09 8.599860000000e-01 1.712914000000e-09 8.599865000000e-01 1.717024000000e-09 8.599868000000e-01 1.722796000000e-09 8.599869000000e-01 1.724262000000e-09 8.599870000000e-01 1.725743000000e-09 8.599871000000e-01 1.730482000000e-09 8.599872000000e-01 1.734128000000e-09 8.599872000000e-01 1.739613000000e-09 8.599873000000e-01 1.743241000000e-09 8.599873000000e-01 1.746998000000e-09 8.599873000000e-01 1.752400000000e-09 8.599873000000e-01 1.756586000000e-09 8.599873000000e-01 1.762468000000e-09 8.599873000000e-01 1.764025000000e-09 8.599873000000e-01 1.765380000000e-09 8.599873000000e-01 1.769719000000e-09 8.599873000000e-01 1.773264000000e-09 8.599873000000e-01 1.778028000000e-09 8.599873000000e-01 1.781718000000e-09 8.599873000000e-01 1.785310000000e-09 8.599873000000e-01 1.790811000000e-09 8.599873000000e-01 1.794844000000e-09 8.599873000000e-01 1.800637000000e-09 8.599873000000e-01 1.802097000000e-09 8.599873000000e-01 1.803580000000e-09 8.599873000000e-01 1.808326000000e-09 8.599873000000e-01 1.811970000000e-09 8.599873000000e-01 1.817496000000e-09 8.599873000000e-01 1.821120000000e-09 8.599873000000e-01 1.824884000000e-09 8.599873000000e-01 1.830308000000e-09 8.599873000000e-01 1.834495000000e-09 8.599873000000e-01 1.840377000000e-09 8.599873000000e-01 1.841939000000e-09 8.599873000000e-01 1.843284000000e-09 8.599873000000e-01 1.847586000000e-09 8.599873000000e-01 1.851115000000e-09 8.599873000000e-01 1.855851000000e-09 8.599873000000e-01 1.859543000000e-09 8.599873000000e-01 1.863125000000e-09 8.599873000000e-01 1.868621000000e-09 8.599873000000e-01 1.872640000000e-09 8.599873000000e-01 1.878406000000e-09 8.599873000000e-01 1.879857000000e-09 8.599873000000e-01 1.881342000000e-09 8.599873000000e-01 1.886097000000e-09 8.599873000000e-01 1.889729000000e-09 8.599873000000e-01 1.895406000000e-09 8.599873000000e-01 1.899019000000e-09 8.599873000000e-01 1.902802000000e-09 8.599873000000e-01 1.908327000000e-09 8.599873000000e-01 1.912510000000e-09 8.599873000000e-01 1.918396000000e-09 8.599873000000e-01 1.923452000000e-09 8.599873000000e-01 1.928319000000e-09 8.599873000000e-01 1.933832000000e-09 8.599873000000e-01 1.937865000000e-09 8.599873000000e-01 1.941516000000e-09 8.599873000000e-01 1.947123000000e-09 8.599873000000e-01 1.951206000000e-09 8.599873000000e-01 1.957151000000e-09 8.599873000000e-01 1.962202000000e-09 8.599873000000e-01 1.967100000000e-09 8.599873000000e-01 1.968013000000e-09 8.599873000000e-01 1.969099000000e-09 8.599873000000e-01 1.972453000000e-09 8.599873000000e-01 1.975701000000e-09 8.599873000000e-01 1.979195000000e-09 8.599875000000e-01 1.983866000000e-09 8.599884000000e-01 1.987814000000e-09 8.599874000000e-01 1.993099000000e-09 8.599866000000e-01 1.998488000000e-09 8.599857000000e-01 2.003935000000e-09 8.599831000000e-01 2.004866000000e-09 8.599830000000e-01 2.005730000000e-09 8.599830000000e-01 2.008495000000e-09 8.599831000000e-01 2.013208000000e-09 8.599791000000e-01 2.016501000000e-09 8.599810000000e-01 2.021215000000e-09 8.600466000000e-01 2.025252000000e-09 8.601222000000e-01 2.030301000000e-09 8.601377000000e-01 2.035760000000e-09 8.600290000000e-01 2.040977000000e-09 8.595439000000e-01 2.042009000000e-09 8.593803000000e-01 2.042812000000e-09 8.592506000000e-01 2.045379000000e-09 8.588055000000e-01 2.049639000000e-09 8.577545000000e-01 2.053254000000e-09 8.561723000000e-01 2.056728000000e-09 8.556773000000e-01 2.062152000000e-09 8.671977000000e-01 2.066039000000e-09 8.849617000000e-01 2.071558000000e-09 9.070712000000e-01 2.076872000000e-09 8.759842000000e-01 2.078300000000e-09 8.450743000000e-01 2.079144000000e-09 8.243845000000e-01 2.081843000000e-09 7.384918000000e-01 2.085459000000e-09 5.906390000000e-01 2.089564000000e-09 4.114100000000e-01 2.093109000000e-09 2.818279000000e-01 2.096789000000e-09 1.812263000000e-01 2.101106000000e-09 1.101406000000e-01 2.105378000000e-09 7.216218000000e-02 2.110838000000e-09 4.407254000000e-02 2.112251000000e-09 3.923662000000e-02 2.113753000000e-09 3.428457000000e-02 2.118558000000e-09 2.023517000000e-02 2.122133000000e-09 1.240054000000e-02 2.129360000000e-09 3.850154000000e-03 2.132821000000e-09 2.214853000000e-03 2.136929000000e-09 1.147412000000e-03 2.139763000000e-09 6.873390000000e-04 2.142597000000e-09 4.529642000000e-04 2.147012000000e-09 2.286409000000e-04 2.152765000000e-09 9.469114000000e-05 2.154377000000e-09 7.724931000000e-05 2.155442000000e-09 6.707215000000e-05 2.158852000000e-09 4.382521000000e-05 2.162621000000e-09 2.922517000000e-05 2.166944000000e-09 1.982127000000e-05 2.170618000000e-09 1.457236000000e-05 2.174167000000e-09 1.144761000000e-05 2.179170000000e-09 8.968959000000e-06 2.183292000000e-09 7.979646000000e-06 2.188867000000e-09 7.115091000000e-06 2.190278000000e-09 6.996929000000e-06 2.191779000000e-09 6.877513000000e-06 2.196584000000e-09 6.618000000000e-06 2.200169000000e-09 6.500869000000e-06 2.207050000000e-09 6.357109000000e-06 2.210543000000e-09 6.319521000000e-06 2.214570000000e-09 6.300838000000e-06 2.217383000000e-09 6.292386000000e-06 2.220196000000e-09 6.287720000000e-06 2.224548000000e-09 6.283061000000e-06 2.230327000000e-09 6.275955000000e-06 2.231668000000e-09 6.275059000000e-06 2.232487000000e-09 6.274509000000e-06 2.235108000000e-09 6.273027000000e-06 2.238430000000e-09 6.271639000000e-06 2.242101000000e-09 6.270664000000e-06 2.245250000000e-09 6.270171000000e-06 2.248623000000e-09 6.269837000000e-06 2.252399000000e-09 6.269628000000e-06 2.256336000000e-09 6.269306000000e-06 2.261919000000e-09 6.269031000000e-06 2.264384000000e-09 6.268997000000e-06 2.265883000000e-09 6.268974000000e-06 2.270679000000e-09 6.268910000000e-06 2.277378000000e-09 6.268862000000e-06 2.283984000000e-09 6.268839000000e-06 2.291963000000e-09 6.268833000000e-06 2.303337000000e-09 6.268822000000e-06 2.323042000000e-09 6.268824000000e-06 2.352076000000e-09 6.268818000000e-06 2.407975000000e-09 6.268821000000e-06 2.543499000000e-09 6.268814000000e-06 2.778736000000e-09 6.268817000000e-06 3.128736000000e-09 6.268811000000e-06 3.478736000000e-09 6.268815000000e-06 3.828736000000e-09 6.268810000000e-06 4.076000000000e-09 6.268815000000e-06 4.076500000000e-09 2.038351000000e-02 4.077000000000e-09 4.008108000000e-02 4.077306000000e-09 3.905965000000e-02 4.077515000000e-09 3.826277000000e-02 4.078112000000e-09 3.572447000000e-02 4.079900000000e-09 2.850892000000e-02 4.082540000000e-09 1.954672000000e-02 4.086501000000e-09 1.039392000000e-02 4.092049000000e-09 3.780384000000e-03 4.100074000000e-09 6.745879000000e-04 4.112222000000e-09 -3.134000000000e-05 4.128358000000e-09 2.199850000000e-05 4.151784000000e-09 -4.195786000000e-06 4.181738000000e-09 1.635177000000e-05 4.223091000000e-09 -1.028040000000e-06 4.287381000000e-09 1.497498000000e-05 4.412795000000e-09 -6.575742000000e-07 4.639879000000e-09 1.494989000000e-05 4.989879000000e-09 -1.076256000000e-06 5.339879000000e-09 1.531126000000e-05 5.689879000000e-09 -1.377751000000e-06 6.039879000000e-09 1.560424000000e-05 6.389879000000e-09 -1.679271000000e-06 6.739879000000e-09 1.585973000000e-05 7.000000000000e-09 -1.969384000000e-06)
V_XOR_26 xor_26 0 PWL(0.000000000000e+00 6.995221000000e-06 1.000000000000e-12 6.997984000000e-06 2.000000000000e-12 7.000502000000e-06 5.200000000000e-12 7.006871000000e-06 1.544000000000e-11 7.014253000000e-06 4.820800000000e-11 7.014547000000e-06 1.530656000000e-10 7.014629000000e-06 4.886099000000e-10 7.014537000000e-06 8.386099000000e-10 7.014631000000e-06 9.995000000000e-10 7.014537000000e-06 9.996500000000e-10 7.014541000000e-06 1.000130000000e-09 7.014550000000e-06 1.000271000000e-09 7.014553000000e-06 1.000500000000e-09 7.014556000000e-06 1.000549000000e-09 7.014557000000e-06 1.000579000000e-09 7.014557000000e-06 1.000674000000e-09 7.014559000000e-06 1.000921000000e-09 7.014561000000e-06 1.001177000000e-09 7.014564000000e-06 1.001636000000e-09 7.014567000000e-06 1.002995000000e-09 7.014574000000e-06 1.004717000000e-09 7.014578000000e-06 1.007157000000e-09 7.014583000000e-06 1.009530000000e-09 7.014585000000e-06 1.012064000000e-09 7.014586000000e-06 1.014479000000e-09 7.014587000000e-06 1.016999000000e-09 7.014587000000e-06 1.019780000000e-09 7.014587000000e-06 1.023006000000e-09 7.014586000000e-06 1.025715000000e-09 7.014586000000e-06 1.028767000000e-09 7.014585000000e-06 1.031545000000e-09 7.014585000000e-06 1.034548000000e-09 7.014585000000e-06 1.037295000000e-09 7.014585000000e-06 1.040188000000e-09 7.014584000000e-06 1.042931000000e-09 7.014584000000e-06 1.046095000000e-09 7.014584000000e-06 1.049020000000e-09 7.014584000000e-06 1.051920000000e-09 7.014584000000e-06 1.055268000000e-09 7.014584000000e-06 1.057963000000e-09 7.014584000000e-06 1.059420000000e-09 7.014584000000e-06 1.060877000000e-09 7.014584000000e-06 1.063981000000e-09 7.014584000000e-06 1.066813000000e-09 7.014584000000e-06 1.069715000000e-09 7.014584000000e-06 1.073141000000e-09 7.014584000000e-06 1.075000000000e-09 7.014584000000e-06 1.075500000000e-09 -2.045888000000e-02 1.075834000000e-09 -3.391895000000e-02 1.076000000000e-09 -4.043046000000e-02 1.076266000000e-09 -3.910846000000e-02 1.076419000000e-09 -3.826786000000e-02 1.076822000000e-09 -3.580912000000e-02 1.078112000000e-09 -2.860479000000e-02 1.079915000000e-09 -2.077672000000e-02 1.082834000000e-09 -1.253811000000e-02 1.086452000000e-09 -6.732495000000e-03 1.089863000000e-09 -3.811584000000e-03 1.094093000000e-09 -1.921680000000e-03 1.097558000000e-09 -1.165444000000e-03 1.101264000000e-09 -7.065968000000e-04 1.105520000000e-09 -4.344229000000e-04 1.109056000000e-09 -2.959289000000e-04 1.112992000000e-09 -2.150839000000e-04 1.115807000000e-09 -1.673405000000e-04 1.118621000000e-09 -1.279798000000e-04 1.121942000000e-09 -1.058274000000e-04 1.125724000000e-09 -7.572432000000e-05 1.129501000000e-09 -6.325419000000e-05 1.133249000000e-09 -4.285618000000e-05 1.135809000000e-09 -3.587983000000e-05 1.138369000000e-09 -3.454717000000e-05 1.141791000000e-09 -2.268023000000e-05 1.145734000000e-09 -1.969633000000e-05 1.150017000000e-09 -1.008217000000e-05 1.153865000000e-09 -1.102567000000e-05 1.158361000000e-09 -4.749440000000e-06 1.161824000000e-09 -6.269396000000e-06 1.165535000000e-09 -1.363388000000e-06 1.169527000000e-09 -3.003995000000e-06 1.173109000000e-09 8.421464000000e-07 1.177056000000e-09 -9.417030000000e-07 1.179535000000e-09 1.080603000000e-07 1.182013000000e-09 2.831825000000e-06 1.185429000000e-09 9.489790000000e-07 1.189651000000e-09 3.474929000000e-06 1.193349000000e-09 2.230154000000e-06 1.197208000000e-09 4.177968000000e-06 1.200595000000e-09 2.903841000000e-06 1.204042000000e-09 4.370437000000e-06 1.207661000000e-09 3.378374000000e-06 1.212044000000e-09 4.811617000000e-06 1.215603000000e-09 3.987105000000e-06 1.219624000000e-09 5.079808000000e-06 1.222280000000e-09 5.068905000000e-06 1.224935000000e-09 4.475380000000e-06 1.228316000000e-09 5.352248000000e-06 1.229186000000e-09 5.237903000000e-06 1.230042000000e-09 5.195260000000e-06 1.232779000000e-09 6.109704000000e-06 1.235670000000e-09 6.042912000000e-06 1.238863000000e-09 6.018341000000e-06 1.243639000000e-09 5.931770000000e-06 1.246999000000e-09 5.993830000000e-06 1.250850000000e-09 5.921389000000e-06 1.255187000000e-09 5.993006000000e-06 1.258822000000e-09 5.926268000000e-06 1.259631000000e-09 5.957749000000e-06 1.260438000000e-09 5.962802000000e-06 1.263021000000e-09 5.962823000000e-06 1.265957000000e-09 5.965540000000e-06 1.269137000000e-09 5.963351000000e-06 1.273131000000e-09 5.966355000000e-06 1.276658000000e-09 5.964789000000e-06 1.280195000000e-09 5.967570000000e-06 1.284359000000e-09 5.966146000000e-06 1.288216000000e-09 5.968609000000e-06 1.291735000000e-09 5.967077000000e-06 1.292574000000e-09 5.968032000000e-06 1.293423000000e-09 5.968182000000e-06 1.296139000000e-09 5.968324000000e-06 1.299136000000e-09 5.968584000000e-06 1.302736000000e-09 5.968716000000e-06 1.306959000000e-09 5.968955000000e-06 1.310392000000e-09 5.969012000000e-06 1.314112000000e-09 5.969168000000e-06 1.317424000000e-09 5.969187000000e-06 1.320972000000e-09 5.969300000000e-06 1.324632000000e-09 5.969303000000e-06 1.327145000000e-09 5.969340000000e-06 1.329658000000e-09 5.969404000000e-06 1.333049000000e-09 5.969388000000e-06 1.337028000000e-09 5.969457000000e-06 1.341293000000e-09 5.969438000000e-06 1.345153000000e-09 5.969493000000e-06 1.349994000000e-09 5.969469000000e-06 1.353616000000e-09 5.969515000000e-06 1.357116000000e-09 5.969486000000e-06 1.357983000000e-09 5.969504000000e-06 1.358962000000e-09 5.969507000000e-06 1.362092000000e-09 5.969510000000e-06 1.364885000000e-09 5.969515000000e-06 1.369987000000e-09 5.969518000000e-06 1.373500000000e-09 5.969522000000e-06 1.377230000000e-09 5.969523000000e-06 1.381288000000e-09 5.969525000000e-06 1.384815000000e-09 5.969526000000e-06 1.388662000000e-09 5.969528000000e-06 1.389532000000e-09 5.969527000000e-06 1.390483000000e-09 5.969528000000e-06 1.393528000000e-09 5.969528000000e-06 1.396267000000e-09 5.969529000000e-06 1.399530000000e-09 5.969529000000e-06 1.403009000000e-09 5.969530000000e-06 1.406745000000e-09 5.969530000000e-06 1.410579000000e-09 5.969530000000e-06 1.413057000000e-09 5.969530000000e-06 1.415535000000e-09 5.969530000000e-06 1.418933000000e-09 5.969531000000e-06 1.419781000000e-09 5.969531000000e-06 1.420563000000e-09 5.969531000000e-06 1.423064000000e-09 5.969531000000e-06 1.426220000000e-09 5.969531000000e-06 1.429627000000e-09 5.969531000000e-06 1.432942000000e-09 5.969531000000e-06 1.436511000000e-09 5.969531000000e-06 1.439973000000e-09 5.969528000000e-06 1.444113000000e-09 5.969538000000e-06 1.447667000000e-09 5.969522000000e-06 1.448597000000e-09 5.969528000000e-06 1.449278000000e-09 5.969532000000e-06 1.451458000000e-09 5.969533000000e-06 1.454984000000e-09 5.969533000000e-06 1.458241000000e-09 5.969572000000e-06 1.461761000000e-09 5.969313000000e-06 1.465886000000e-09 5.969900000000e-06 1.469389000000e-09 5.969271000000e-06 1.472794000000e-09 5.969546000000e-06 1.475276000000e-09 5.969692000000e-06 1.477758000000e-09 5.969792000000e-06 1.479095000000e-09 5.974781000000e-06 1.479882000000e-09 5.955361000000e-06 1.482402000000e-09 5.968592000000e-06 1.485321000000e-09 5.976127000000e-06 1.488790000000e-09 5.964893000000e-06 1.492381000000e-09 5.967604000000e-06 1.496661000000e-09 5.980997000000e-06 1.500576000000e-09 6.271257000000e-06 1.504103000000e-09 5.588490000000e-06 1.508121000000e-09 5.731372000000e-06 1.509046000000e-09 5.724911000000e-06 1.509764000000e-09 5.988779000000e-06 1.512062000000e-09 5.512428000000e-06 1.514727000000e-09 5.703869000000e-06 1.518391000000e-09 7.585961000000e-06 1.521668000000e-09 1.165756000000e-05 1.525243000000e-09 2.684512000000e-05 1.529365000000e-09 -1.935530000000e-06 1.532875000000e-09 -4.343584000000e-05 1.534025000000e-09 -6.752803000000e-05 1.534117000000e-09 -1.420896000000e-03 1.534180000000e-09 -2.344802000000e-03 1.534382000000e-09 -5.003333000000e-03 1.534737000000e-09 -8.820197000000e-03 1.535025000000e-09 -1.104779000000e-02 1.535086000000e-09 -1.059377000000e-02 1.535120000000e-09 -1.033662000000e-02 1.535227000000e-09 -9.557806000000e-03 1.535516000000e-09 -7.684523000000e-03 1.535770000000e-09 -6.294311000000e-03 1.536253000000e-09 -4.142941000000e-03 1.537797000000e-09 1.142342000000e-04 1.540037000000e-09 2.692994000000e-03 1.542991000000e-09 3.509085000000e-03 1.546340000000e-09 2.819463000000e-03 1.549563000000e-09 1.504716000000e-03 1.553023000000e-09 -2.814879000000e-03 1.556674000000e-09 -1.241291000000e-02 1.561332000000e-09 -2.027310000000e-02 1.564959000000e-09 6.733885000000e-03 1.568637000000e-09 8.647828000000e-02 1.572862000000e-09 2.020249000000e-01 1.576410000000e-09 2.851599000000e-01 1.580380000000e-09 3.695270000000e-01 1.584817000000e-09 4.722402000000e-01 1.588226000000e-09 5.511236000000e-01 1.592181000000e-09 6.274281000000e-01 1.595925000000e-09 6.788307000000e-01 1.599741000000e-09 7.150190000000e-01 1.604581000000e-09 7.481829000000e-01 1.606342000000e-09 7.587332000000e-01 1.608103000000e-09 7.684759000000e-01 1.611836000000e-09 7.896382000000e-01 1.616035000000e-09 8.105953000000e-01 1.619218000000e-09 8.228997000000e-01 1.623182000000e-09 8.342013000000e-01 1.626358000000e-09 8.407396000000e-01 1.629985000000e-09 8.462287000000e-01 1.634074000000e-09 8.505850000000e-01 1.638238000000e-09 8.536101000000e-01 1.643068000000e-09 8.559363000000e-01 1.648476000000e-09 8.575548000000e-01 1.653917000000e-09 8.585344000000e-01 1.658595000000e-09 8.590496000000e-01 1.665047000000e-09 8.594827000000e-01 1.668427000000e-09 8.596167000000e-01 1.674362000000e-09 8.597791000000e-01 1.678501000000e-09 8.598429000000e-01 1.684581000000e-09 8.599092000000e-01 1.686093000000e-09 8.599177000000e-01 1.687486000000e-09 8.599246000000e-01 1.691945000000e-09 8.599474000000e-01 1.695547000000e-09 8.599581000000e-01 1.700342000000e-09 8.599689000000e-01 1.704014000000e-09 8.599740000000e-01 1.707642000000e-09 8.599781000000e-01 1.712914000000e-09 8.599814000000e-01 1.717024000000e-09 8.599836000000e-01 1.722796000000e-09 8.599848000000e-01 1.724262000000e-09 8.599853000000e-01 1.725743000000e-09 8.599856000000e-01 1.730482000000e-09 8.599862000000e-01 1.734128000000e-09 8.599865000000e-01 1.739613000000e-09 8.599868000000e-01 1.743241000000e-09 8.599870000000e-01 1.746998000000e-09 8.599871000000e-01 1.752400000000e-09 8.599872000000e-01 1.756586000000e-09 8.599872000000e-01 1.762468000000e-09 8.599872000000e-01 1.764025000000e-09 8.599872000000e-01 1.765380000000e-09 8.599873000000e-01 1.769719000000e-09 8.599873000000e-01 1.773264000000e-09 8.599873000000e-01 1.778028000000e-09 8.599873000000e-01 1.781718000000e-09 8.599873000000e-01 1.785310000000e-09 8.599873000000e-01 1.790811000000e-09 8.599873000000e-01 1.794844000000e-09 8.599873000000e-01 1.800637000000e-09 8.599873000000e-01 1.802097000000e-09 8.599873000000e-01 1.803580000000e-09 8.599873000000e-01 1.808326000000e-09 8.599873000000e-01 1.811970000000e-09 8.599873000000e-01 1.817496000000e-09 8.599873000000e-01 1.821120000000e-09 8.599873000000e-01 1.824884000000e-09 8.599873000000e-01 1.830308000000e-09 8.599873000000e-01 1.834495000000e-09 8.599873000000e-01 1.840377000000e-09 8.599873000000e-01 1.841939000000e-09 8.599873000000e-01 1.843284000000e-09 8.599873000000e-01 1.847586000000e-09 8.599873000000e-01 1.851115000000e-09 8.599873000000e-01 1.855851000000e-09 8.599873000000e-01 1.859543000000e-09 8.599873000000e-01 1.863125000000e-09 8.599873000000e-01 1.868621000000e-09 8.599873000000e-01 1.872640000000e-09 8.599873000000e-01 1.878406000000e-09 8.599873000000e-01 1.879857000000e-09 8.599873000000e-01 1.881342000000e-09 8.599873000000e-01 1.886097000000e-09 8.599873000000e-01 1.889729000000e-09 8.599873000000e-01 1.895406000000e-09 8.599873000000e-01 1.899019000000e-09 8.599873000000e-01 1.902802000000e-09 8.599873000000e-01 1.908327000000e-09 8.599873000000e-01 1.912510000000e-09 8.599873000000e-01 1.918396000000e-09 8.599873000000e-01 1.923452000000e-09 8.599873000000e-01 1.928319000000e-09 8.599873000000e-01 1.933832000000e-09 8.599873000000e-01 1.937865000000e-09 8.599873000000e-01 1.941516000000e-09 8.599873000000e-01 1.947123000000e-09 8.599873000000e-01 1.951206000000e-09 8.599873000000e-01 1.957151000000e-09 8.599873000000e-01 1.962202000000e-09 8.599873000000e-01 1.967100000000e-09 8.599873000000e-01 1.968013000000e-09 8.599873000000e-01 1.969099000000e-09 8.599873000000e-01 1.972453000000e-09 8.599873000000e-01 1.975701000000e-09 8.599873000000e-01 1.979195000000e-09 8.599873000000e-01 1.983866000000e-09 8.599873000000e-01 1.987814000000e-09 8.599873000000e-01 1.993099000000e-09 8.599873000000e-01 1.998488000000e-09 8.599873000000e-01 2.003935000000e-09 8.599873000000e-01 2.004866000000e-09 8.599873000000e-01 2.005730000000e-09 8.599873000000e-01 2.008495000000e-09 8.599873000000e-01 2.013208000000e-09 8.599873000000e-01 2.016501000000e-09 8.599873000000e-01 2.021215000000e-09 8.599878000000e-01 2.025252000000e-09 8.599877000000e-01 2.030301000000e-09 8.599869000000e-01 2.035760000000e-09 8.599862000000e-01 2.040977000000e-09 8.599839000000e-01 2.042009000000e-09 8.599834000000e-01 2.042812000000e-09 8.599832000000e-01 2.045379000000e-09 8.599833000000e-01 2.049639000000e-09 8.599821000000e-01 2.053254000000e-09 8.599766000000e-01 2.056728000000e-09 8.599936000000e-01 2.062152000000e-09 8.600859000000e-01 2.066039000000e-09 8.601367000000e-01 2.071558000000e-09 8.601206000000e-01 2.076872000000e-09 8.598759000000e-01 2.078300000000e-09 8.597241000000e-01 2.079144000000e-09 8.596200000000e-01 2.081843000000e-09 8.592192000000e-01 2.085459000000e-09 8.585605000000e-01 2.089564000000e-09 8.573526000000e-01 2.093109000000e-09 8.557204000000e-01 2.096789000000e-09 8.566763000000e-01 2.101106000000e-09 8.677979000000e-01 2.105378000000e-09 8.875643000000e-01 2.110838000000e-09 9.076792000000e-01 2.112251000000e-09 9.066974000000e-01 2.113753000000e-09 9.014921000000e-01 2.118558000000e-09 8.165217000000e-01 2.122133000000e-09 6.889517000000e-01 2.129360000000e-09 3.837060000000e-01 2.132821000000e-09 2.596155000000e-01 2.136929000000e-09 1.575199000000e-01 2.139763000000e-09 1.112408000000e-01 2.142597000000e-09 8.469085000000e-02 2.147012000000e-09 5.651523000000e-02 2.152765000000e-09 3.369230000000e-02 2.154377000000e-09 2.887821000000e-02 2.155442000000e-09 2.577189000000e-02 2.158852000000e-09 1.705327000000e-02 2.162621000000e-09 1.004764000000e-02 2.166944000000e-09 5.198395000000e-03 2.170618000000e-09 2.935430000000e-03 2.174167000000e-09 1.681014000000e-03 2.179170000000e-09 7.468620000000e-04 2.183292000000e-09 3.925738000000e-04 2.188867000000e-09 1.635047000000e-04 2.190278000000e-09 1.360042000000e-04 2.191779000000e-09 1.097452000000e-04 2.196584000000e-09 5.623300000000e-05 2.200169000000e-09 3.687117000000e-05 2.207050000000e-09 1.855861000000e-05 2.210543000000e-09 1.388983000000e-05 2.214570000000e-09 1.065331000000e-05 2.217383000000e-09 9.185204000000e-06 2.220196000000e-09 8.369490000000e-06 2.224548000000e-09 7.511901000000e-06 2.230327000000e-09 6.901066000000e-06 2.231668000000e-09 6.822284000000e-06 2.232487000000e-09 6.775178000000e-06 2.235108000000e-09 6.647711000000e-06 2.238430000000e-09 6.524828000000e-06 2.242101000000e-09 6.425280000000e-06 2.245250000000e-09 6.366163000000e-06 2.248623000000e-09 6.325001000000e-06 2.252399000000e-09 6.306196000000e-06 2.256336000000e-09 6.292467000000e-06 2.261919000000e-09 6.277904000000e-06 2.264384000000e-09 6.274951000000e-06 2.265883000000e-09 6.273365000000e-06 2.270679000000e-09 6.269788000000e-06 2.277378000000e-09 6.266791000000e-06 2.283984000000e-09 6.265019000000e-06 2.291963000000e-09 6.264318000000e-06 2.303337000000e-09 6.263667000000e-06 2.323042000000e-09 6.263676000000e-06 2.352076000000e-09 6.263624000000e-06 2.407975000000e-09 6.263628000000e-06 2.543499000000e-09 6.263636000000e-06 2.778736000000e-09 6.263617000000e-06 3.128736000000e-09 6.263636000000e-06 3.478736000000e-09 6.263614000000e-06 3.828736000000e-09 6.263638000000e-06 4.076000000000e-09 6.263611000000e-06 4.076500000000e-09 2.038301000000e-02 4.077000000000e-09 4.008044000000e-02 4.077306000000e-09 3.905896000000e-02 4.077515000000e-09 3.826206000000e-02 4.078112000000e-09 3.572370000000e-02 4.079900000000e-09 2.850816000000e-02 4.082540000000e-09 1.954614000000e-02 4.086501000000e-09 1.039359000000e-02 4.092049000000e-09 3.780259000000e-03 4.100074000000e-09 6.745675000000e-04 4.112222000000e-09 -3.133900000000e-05 4.128358000000e-09 2.199821000000e-05 4.151784000000e-09 -4.195540000000e-06 4.181738000000e-09 1.635162000000e-05 4.223091000000e-09 -1.027822000000e-06 4.287381000000e-09 1.497488000000e-05 4.412795000000e-09 -6.573614000000e-07 4.639879000000e-09 1.494980000000e-05 4.989879000000e-09 -1.076045000000e-06 5.339879000000e-09 1.531118000000e-05 5.689879000000e-09 -1.377550000000e-06 6.039879000000e-09 1.560417000000e-05 6.389879000000e-09 -1.679078000000e-06 6.739879000000e-09 1.585967000000e-05 7.000000000000e-09 -1.969198000000e-06)
V_XOR_27 xor_27 0 PWL(0.000000000000e+00 6.995221000000e-06 1.000000000000e-12 6.997984000000e-06 2.000000000000e-12 7.000502000000e-06 5.200000000000e-12 7.006871000000e-06 1.544000000000e-11 7.014253000000e-06 4.820800000000e-11 7.014547000000e-06 1.530656000000e-10 7.014629000000e-06 4.886099000000e-10 7.014537000000e-06 8.386099000000e-10 7.014631000000e-06 9.995000000000e-10 7.014537000000e-06 9.996500000000e-10 7.014541000000e-06 1.000130000000e-09 7.014550000000e-06 1.000271000000e-09 7.014553000000e-06 1.000500000000e-09 7.014556000000e-06 1.000549000000e-09 7.014557000000e-06 1.000579000000e-09 7.014557000000e-06 1.000674000000e-09 7.014559000000e-06 1.000921000000e-09 7.014561000000e-06 1.001177000000e-09 7.014564000000e-06 1.001636000000e-09 7.014567000000e-06 1.002995000000e-09 7.014574000000e-06 1.004717000000e-09 7.014578000000e-06 1.007157000000e-09 7.014583000000e-06 1.009530000000e-09 7.014585000000e-06 1.012064000000e-09 7.014586000000e-06 1.014479000000e-09 7.014587000000e-06 1.016999000000e-09 7.014587000000e-06 1.019780000000e-09 7.014587000000e-06 1.023006000000e-09 7.014586000000e-06 1.025715000000e-09 7.014586000000e-06 1.028767000000e-09 7.014585000000e-06 1.031545000000e-09 7.014585000000e-06 1.034548000000e-09 7.014585000000e-06 1.037295000000e-09 7.014585000000e-06 1.040188000000e-09 7.014584000000e-06 1.042931000000e-09 7.014584000000e-06 1.046095000000e-09 7.014584000000e-06 1.049020000000e-09 7.014584000000e-06 1.051920000000e-09 7.014584000000e-06 1.055268000000e-09 7.014584000000e-06 1.057963000000e-09 7.014584000000e-06 1.059420000000e-09 7.014584000000e-06 1.060877000000e-09 7.014584000000e-06 1.063981000000e-09 7.014584000000e-06 1.066813000000e-09 7.014584000000e-06 1.069715000000e-09 7.014584000000e-06 1.073141000000e-09 7.014584000000e-06 1.075000000000e-09 7.014584000000e-06 1.075500000000e-09 -2.045874000000e-02 1.075834000000e-09 -3.391872000000e-02 1.076000000000e-09 -4.043020000000e-02 1.076266000000e-09 -3.910829000000e-02 1.076419000000e-09 -3.826775000000e-02 1.076822000000e-09 -3.580916000000e-02 1.078112000000e-09 -2.860505000000e-02 1.079915000000e-09 -2.077684000000e-02 1.082834000000e-09 -1.253798000000e-02 1.086452000000e-09 -6.732441000000e-03 1.089863000000e-09 -3.811612000000e-03 1.094093000000e-09 -1.921703000000e-03 1.097558000000e-09 -1.165451000000e-03 1.101264000000e-09 -7.065972000000e-04 1.105520000000e-09 -4.344196000000e-04 1.109056000000e-09 -2.959279000000e-04 1.112992000000e-09 -2.150800000000e-04 1.115807000000e-09 -1.673385000000e-04 1.118621000000e-09 -1.279831000000e-04 1.121942000000e-09 -1.058277000000e-04 1.125724000000e-09 -7.572036000000e-05 1.129501000000e-09 -6.325797000000e-05 1.133249000000e-09 -4.285522000000e-05 1.135809000000e-09 -3.587796000000e-05 1.138369000000e-09 -3.454630000000e-05 1.141791000000e-09 -2.268193000000e-05 1.145734000000e-09 -1.969452000000e-05 1.150017000000e-09 -1.008256000000e-05 1.153865000000e-09 -1.102632000000e-05 1.158361000000e-09 -4.749416000000e-06 1.161824000000e-09 -6.268995000000e-06 1.165535000000e-09 -1.363546000000e-06 1.169527000000e-09 -3.003736000000e-06 1.173109000000e-09 8.419292000000e-07 1.177056000000e-09 -9.414368000000e-07 1.179535000000e-09 1.082348000000e-07 1.182013000000e-09 2.831602000000e-06 1.185429000000e-09 9.492396000000e-07 1.189651000000e-09 3.474725000000e-06 1.193349000000e-09 2.230413000000e-06 1.197208000000e-09 4.177761000000e-06 1.200595000000e-09 2.904110000000e-06 1.204042000000e-09 4.370237000000e-06 1.207661000000e-09 3.378635000000e-06 1.212044000000e-09 4.811408000000e-06 1.215603000000e-09 3.987360000000e-06 1.219624000000e-09 5.079613000000e-06 1.222280000000e-09 5.068781000000e-06 1.224935000000e-09 4.475621000000e-06 1.228316000000e-09 5.352048000000e-06 1.229186000000e-09 5.237929000000e-06 1.230042000000e-09 5.195266000000e-06 1.232779000000e-09 6.109673000000e-06 1.235670000000e-09 6.042979000000e-06 1.238863000000e-09 6.018298000000e-06 1.243639000000e-09 5.931817000000e-06 1.246999000000e-09 5.993857000000e-06 1.250850000000e-09 5.921413000000e-06 1.255187000000e-09 5.993031000000e-06 1.258822000000e-09 5.926300000000e-06 1.259631000000e-09 5.957771000000e-06 1.260438000000e-09 5.962750000000e-06 1.263021000000e-09 5.962910000000e-06 1.265957000000e-09 5.965425000000e-06 1.269137000000e-09 5.963281000000e-06 1.273131000000e-09 5.966337000000e-06 1.276658000000e-09 5.964760000000e-06 1.280195000000e-09 5.967542000000e-06 1.284359000000e-09 5.966113000000e-06 1.288216000000e-09 5.968576000000e-06 1.291735000000e-09 5.967040000000e-06 1.292574000000e-09 5.967998000000e-06 1.293423000000e-09 5.968147000000e-06 1.296139000000e-09 5.968289000000e-06 1.299136000000e-09 5.968549000000e-06 1.302736000000e-09 5.968680000000e-06 1.306959000000e-09 5.968919000000e-06 1.310392000000e-09 5.968977000000e-06 1.314112000000e-09 5.969131000000e-06 1.317424000000e-09 5.969151000000e-06 1.320972000000e-09 5.969264000000e-06 1.324632000000e-09 5.969267000000e-06 1.327145000000e-09 5.969304000000e-06 1.329658000000e-09 5.969368000000e-06 1.333049000000e-09 5.969352000000e-06 1.337028000000e-09 5.969421000000e-06 1.341293000000e-09 5.969402000000e-06 1.345153000000e-09 5.969457000000e-06 1.349994000000e-09 5.969433000000e-06 1.353616000000e-09 5.969479000000e-06 1.357116000000e-09 5.969450000000e-06 1.357983000000e-09 5.969468000000e-06 1.358962000000e-09 5.969471000000e-06 1.362092000000e-09 5.969474000000e-06 1.364885000000e-09 5.969479000000e-06 1.369987000000e-09 5.969482000000e-06 1.373500000000e-09 5.969486000000e-06 1.377230000000e-09 5.969487000000e-06 1.381288000000e-09 5.969489000000e-06 1.384815000000e-09 5.969490000000e-06 1.388662000000e-09 5.969492000000e-06 1.389532000000e-09 5.969491000000e-06 1.390483000000e-09 5.969492000000e-06 1.393528000000e-09 5.969492000000e-06 1.396267000000e-09 5.969493000000e-06 1.399530000000e-09 5.969493000000e-06 1.403009000000e-09 5.969494000000e-06 1.406745000000e-09 5.969494000000e-06 1.410579000000e-09 5.969494000000e-06 1.413057000000e-09 5.969494000000e-06 1.415535000000e-09 5.969494000000e-06 1.418933000000e-09 5.969495000000e-06 1.419781000000e-09 5.969495000000e-06 1.420563000000e-09 5.969495000000e-06 1.423064000000e-09 5.969495000000e-06 1.426220000000e-09 5.969495000000e-06 1.429627000000e-09 5.969495000000e-06 1.432942000000e-09 5.969495000000e-06 1.436511000000e-09 5.969495000000e-06 1.439973000000e-09 5.969495000000e-06 1.444113000000e-09 5.969495000000e-06 1.447667000000e-09 5.969495000000e-06 1.448597000000e-09 5.969495000000e-06 1.449278000000e-09 5.969495000000e-06 1.451458000000e-09 5.969495000000e-06 1.454984000000e-09 5.969495000000e-06 1.458241000000e-09 5.969496000000e-06 1.461761000000e-09 5.969492000000e-06 1.465886000000e-09 5.969503000000e-06 1.469389000000e-09 5.969485000000e-06 1.472794000000e-09 5.969501000000e-06 1.475276000000e-09 5.969503000000e-06 1.477758000000e-09 5.969495000000e-06 1.479095000000e-09 5.969562000000e-06 1.479882000000e-09 5.969044000000e-06 1.482402000000e-09 5.969733000000e-06 1.485321000000e-09 5.969566000000e-06 1.488790000000e-09 5.969268000000e-06 1.492381000000e-09 5.969597000000e-06 1.496661000000e-09 5.969543000000e-06 1.500576000000e-09 5.972218000000e-06 1.504103000000e-09 5.957937000000e-06 1.508121000000e-09 5.978617000000e-06 1.509046000000e-09 5.975304000000e-06 1.509764000000e-09 5.978307000000e-06 1.512062000000e-09 5.963538000000e-06 1.514727000000e-09 5.969302000000e-06 1.518391000000e-09 5.987906000000e-06 1.521668000000e-09 6.322765000000e-06 1.525243000000e-09 5.558348000000e-06 1.529365000000e-09 5.737778000000e-06 1.532875000000e-09 5.793417000000e-06 1.534025000000e-09 5.632892000000e-06 1.534117000000e-09 -1.325603000000e-03 1.534180000000e-09 -2.244316000000e-03 1.534382000000e-09 -4.905021000000e-03 1.534737000000e-09 -8.711946000000e-03 1.535025000000e-09 -1.093940000000e-02 1.535086000000e-09 -1.048322000000e-02 1.535120000000e-09 -1.022538000000e-02 1.535227000000e-09 -9.445494000000e-03 1.535516000000e-09 -7.568835000000e-03 1.535770000000e-09 -6.175952000000e-03 1.536253000000e-09 -4.020660000000e-03 1.537797000000e-09 2.389631000000e-04 1.540037000000e-09 2.653117000000e-03 1.542991000000e-09 2.900325000000e-03 1.546340000000e-09 1.555468000000e-03 1.549563000000e-09 4.607459000000e-04 1.553023000000e-09 -1.945259000000e-04 1.556674000000e-09 -4.505894000000e-04 1.561332000000e-09 -2.262814000000e-04 1.564959000000e-09 4.998762000000e-04 1.568637000000e-09 1.264579000000e-03 1.572862000000e-09 -7.334496000000e-04 1.576410000000e-09 -7.535923000000e-03 1.580380000000e-09 -2.037707000000e-02 1.584817000000e-09 -8.532123000000e-03 1.588226000000e-09 4.751848000000e-02 1.592181000000e-09 1.526543000000e-01 1.595925000000e-09 2.489472000000e-01 1.599741000000e-09 3.311261000000e-01 1.604581000000e-09 4.390619000000e-01 1.606342000000e-09 4.802370000000e-01 1.608103000000e-09 5.224315000000e-01 1.611836000000e-09 6.010585000000e-01 1.616035000000e-09 6.664378000000e-01 1.619218000000e-09 7.005422000000e-01 1.623182000000e-09 7.318287000000e-01 1.626358000000e-09 7.516502000000e-01 1.629985000000e-09 7.725858000000e-01 1.634074000000e-09 7.954438000000e-01 1.638238000000e-09 8.150154000000e-01 1.643068000000e-09 8.310914000000e-01 1.648476000000e-09 8.425303000000e-01 1.653917000000e-09 8.495064000000e-01 1.658595000000e-09 8.532214000000e-01 1.665047000000e-09 8.563244000000e-01 1.668427000000e-09 8.573151000000e-01 1.674362000000e-09 8.584652000000e-01 1.678501000000e-09 8.589554000000e-01 1.684581000000e-09 8.594077000000e-01 1.686093000000e-09 8.594796000000e-01 1.687486000000e-09 8.595399000000e-01 1.691945000000e-09 8.596941000000e-01 1.695547000000e-09 8.597774000000e-01 1.700342000000e-09 8.598541000000e-01 1.704014000000e-09 8.598924000000e-01 1.707642000000e-09 8.599199000000e-01 1.712914000000e-09 8.599462000000e-01 1.717024000000e-09 8.599595000000e-01 1.722796000000e-09 8.599711000000e-01 1.724262000000e-09 8.599731000000e-01 1.725743000000e-09 8.599749000000e-01 1.730482000000e-09 8.599794000000e-01 1.734128000000e-09 8.599817000000e-01 1.739613000000e-09 8.599840000000e-01 1.743241000000e-09 8.599849000000e-01 1.746998000000e-09 8.599856000000e-01 1.752400000000e-09 8.599863000000e-01 1.756586000000e-09 8.599866000000e-01 1.762468000000e-09 8.599869000000e-01 1.764025000000e-09 8.599870000000e-01 1.765380000000e-09 8.599870000000e-01 1.769719000000e-09 8.599871000000e-01 1.773264000000e-09 8.599872000000e-01 1.778028000000e-09 8.599872000000e-01 1.781718000000e-09 8.599873000000e-01 1.785310000000e-09 8.599873000000e-01 1.790811000000e-09 8.599873000000e-01 1.794844000000e-09 8.599873000000e-01 1.800637000000e-09 8.599873000000e-01 1.802097000000e-09 8.599873000000e-01 1.803580000000e-09 8.599873000000e-01 1.808326000000e-09 8.599873000000e-01 1.811970000000e-09 8.599873000000e-01 1.817496000000e-09 8.599873000000e-01 1.821120000000e-09 8.599873000000e-01 1.824884000000e-09 8.599873000000e-01 1.830308000000e-09 8.599873000000e-01 1.834495000000e-09 8.599873000000e-01 1.840377000000e-09 8.599873000000e-01 1.841939000000e-09 8.599873000000e-01 1.843284000000e-09 8.599873000000e-01 1.847586000000e-09 8.599873000000e-01 1.851115000000e-09 8.599873000000e-01 1.855851000000e-09 8.599873000000e-01 1.859543000000e-09 8.599873000000e-01 1.863125000000e-09 8.599873000000e-01 1.868621000000e-09 8.599873000000e-01 1.872640000000e-09 8.599873000000e-01 1.878406000000e-09 8.599873000000e-01 1.879857000000e-09 8.599873000000e-01 1.881342000000e-09 8.599873000000e-01 1.886097000000e-09 8.599873000000e-01 1.889729000000e-09 8.599873000000e-01 1.895406000000e-09 8.599873000000e-01 1.899019000000e-09 8.599873000000e-01 1.902802000000e-09 8.599873000000e-01 1.908327000000e-09 8.599873000000e-01 1.912510000000e-09 8.599873000000e-01 1.918396000000e-09 8.599873000000e-01 1.923452000000e-09 8.599873000000e-01 1.928319000000e-09 8.599873000000e-01 1.933832000000e-09 8.599873000000e-01 1.937865000000e-09 8.599873000000e-01 1.941516000000e-09 8.599873000000e-01 1.947123000000e-09 8.599873000000e-01 1.951206000000e-09 8.599873000000e-01 1.957151000000e-09 8.599873000000e-01 1.962202000000e-09 8.599873000000e-01 1.967100000000e-09 8.599873000000e-01 1.968013000000e-09 8.599873000000e-01 1.969099000000e-09 8.599873000000e-01 1.972453000000e-09 8.599873000000e-01 1.975701000000e-09 8.599873000000e-01 1.979195000000e-09 8.599873000000e-01 1.983866000000e-09 8.599873000000e-01 1.987814000000e-09 8.599873000000e-01 1.993099000000e-09 8.599873000000e-01 1.998488000000e-09 8.599873000000e-01 2.003935000000e-09 8.599873000000e-01 2.004866000000e-09 8.599873000000e-01 2.005730000000e-09 8.599873000000e-01 2.008495000000e-09 8.599873000000e-01 2.013208000000e-09 8.599873000000e-01 2.016501000000e-09 8.599873000000e-01 2.021215000000e-09 8.599873000000e-01 2.025252000000e-09 8.599873000000e-01 2.030301000000e-09 8.599873000000e-01 2.035760000000e-09 8.599873000000e-01 2.040977000000e-09 8.599873000000e-01 2.042009000000e-09 8.599873000000e-01 2.042812000000e-09 8.599873000000e-01 2.045379000000e-09 8.599873000000e-01 2.049639000000e-09 8.599873000000e-01 2.053254000000e-09 8.599873000000e-01 2.056728000000e-09 8.599875000000e-01 2.062152000000e-09 8.599879000000e-01 2.066039000000e-09 8.599874000000e-01 2.071558000000e-09 8.599867000000e-01 2.076872000000e-09 8.599853000000e-01 2.078300000000e-09 8.599847000000e-01 2.079144000000e-09 8.599841000000e-01 2.081843000000e-09 8.599832000000e-01 2.085459000000e-09 8.599833000000e-01 2.089564000000e-09 8.599809000000e-01 2.093109000000e-09 8.599777000000e-01 2.096789000000e-09 8.600104000000e-01 2.101106000000e-09 8.600927000000e-01 2.105378000000e-09 8.601389000000e-01 2.110838000000e-09 8.601120000000e-01 2.112251000000e-09 8.600825000000e-01 2.113753000000e-09 8.600257000000e-01 2.118558000000e-09 8.595378000000e-01 2.122133000000e-09 8.589524000000e-01 2.129360000000e-09 8.568155000000e-01 2.132821000000e-09 8.553985000000e-01 2.136929000000e-09 8.585987000000e-01 2.139763000000e-09 8.662893000000e-01 2.142597000000e-09 8.784567000000e-01 2.147012000000e-09 8.997225000000e-01 2.152765000000e-09 8.972409000000e-01 2.154377000000e-09 8.774586000000e-01 2.155442000000e-09 8.609608000000e-01 2.158852000000e-09 7.705002000000e-01 2.162621000000e-09 6.230017000000e-01 2.166944000000e-09 4.328823000000e-01 2.170618000000e-09 2.943395000000e-01 2.174167000000e-09 1.929712000000e-01 2.179170000000e-09 1.079039000000e-01 2.183292000000e-09 7.206945000000e-02 2.188867000000e-09 4.352832000000e-02 2.190278000000e-09 3.876113000000e-02 2.191779000000e-09 3.385517000000e-02 2.196584000000e-09 1.993056000000e-02 2.200169000000e-09 1.217448000000e-02 2.207050000000e-09 4.040002000000e-03 2.210543000000e-09 2.318348000000e-03 2.214570000000e-09 1.219302000000e-03 2.217383000000e-09 7.352755000000e-04 2.220196000000e-09 4.847226000000e-04 2.224548000000e-09 2.466540000000e-04 2.230327000000e-09 1.019872000000e-04 2.231668000000e-09 8.573749000000e-05 2.232487000000e-09 7.675373000000e-05 2.235108000000e-09 5.474398000000e-05 2.238430000000e-09 3.714812000000e-05 2.242101000000e-09 2.564958000000e-05 2.245250000000e-09 1.948535000000e-05 2.248623000000e-09 1.439336000000e-05 2.252399000000e-09 1.125406000000e-05 2.256336000000e-09 9.421695000000e-06 2.261919000000e-09 7.811928000000e-06 2.264384000000e-09 7.438253000000e-06 2.265883000000e-09 7.229557000000e-06 2.270679000000e-09 6.774199000000e-06 2.277378000000e-09 6.472924000000e-06 2.283984000000e-09 6.335452000000e-06 2.291963000000e-09 6.280680000000e-06 2.303337000000e-09 6.247071000000e-06 2.323042000000e-09 6.227660000000e-06 2.352076000000e-09 6.234417000000e-06 2.407975000000e-09 6.231112000000e-06 2.543499000000e-09 6.233446000000e-06 2.778736000000e-09 6.231458000000e-06 3.128736000000e-09 6.233246000000e-06 3.478736000000e-09 6.231604000000e-06 3.828736000000e-09 6.233105000000e-06 4.076000000000e-09 6.231763000000e-06 4.076500000000e-09 2.038286000000e-02 4.077000000000e-09 4.008035000000e-02 4.077306000000e-09 3.905885000000e-02 4.077515000000e-09 3.826192000000e-02 4.078112000000e-09 3.572352000000e-02 4.079900000000e-09 2.850804000000e-02 4.082540000000e-09 1.954623000000e-02 4.086501000000e-09 1.039378000000e-02 4.092049000000e-09 3.780319000000e-03 4.100074000000e-09 6.745529000000e-04 4.112222000000e-09 -3.132433000000e-05 4.128358000000e-09 2.199154000000e-05 4.151784000000e-09 -4.191955000000e-06 4.181738000000e-09 1.635062000000e-05 4.223091000000e-09 -1.027110000000e-06 4.287381000000e-09 1.497521000000e-05 4.412795000000e-09 -6.573770000000e-07 4.639879000000e-09 1.495036000000e-05 4.989879000000e-09 -1.076221000000e-06 5.339879000000e-09 1.531190000000e-05 5.689879000000e-09 -1.377878000000e-06 6.039879000000e-09 1.560502000000e-05 6.389879000000e-09 -1.679537000000e-06 6.739879000000e-09 1.586064000000e-05 7.000000000000e-09 -1.969794000000e-06)
V_XOR_28 xor_28 0 PWL(0.000000000000e+00 6.995221000000e-06 1.000000000000e-12 6.997985000000e-06 2.000000000000e-12 7.000502000000e-06 5.200000000000e-12 7.006871000000e-06 1.544000000000e-11 7.014253000000e-06 4.820800000000e-11 7.014547000000e-06 1.530656000000e-10 7.014629000000e-06 4.886099000000e-10 7.014537000000e-06 8.386099000000e-10 7.014631000000e-06 9.995000000000e-10 7.014537000000e-06 9.996500000000e-10 7.014541000000e-06 1.000130000000e-09 7.014550000000e-06 1.000271000000e-09 7.014553000000e-06 1.000500000000e-09 7.014556000000e-06 1.000549000000e-09 7.014557000000e-06 1.000579000000e-09 7.014557000000e-06 1.000674000000e-09 7.014558000000e-06 1.000921000000e-09 7.014561000000e-06 1.001177000000e-09 7.014563000000e-06 1.001636000000e-09 7.014567000000e-06 1.002995000000e-09 7.014573000000e-06 1.004717000000e-09 7.014578000000e-06 1.007157000000e-09 7.014583000000e-06 1.009530000000e-09 7.014585000000e-06 1.012064000000e-09 7.014586000000e-06 1.014479000000e-09 7.014587000000e-06 1.016999000000e-09 7.014587000000e-06 1.019780000000e-09 7.014587000000e-06 1.023006000000e-09 7.014586000000e-06 1.025715000000e-09 7.014586000000e-06 1.028767000000e-09 7.014585000000e-06 1.031545000000e-09 7.014585000000e-06 1.034548000000e-09 7.014585000000e-06 1.037295000000e-09 7.014585000000e-06 1.040188000000e-09 7.014584000000e-06 1.042931000000e-09 7.014584000000e-06 1.046095000000e-09 7.014584000000e-06 1.049020000000e-09 7.014584000000e-06 1.051920000000e-09 7.014584000000e-06 1.055268000000e-09 7.014584000000e-06 1.057963000000e-09 7.014584000000e-06 1.059420000000e-09 7.014584000000e-06 1.060877000000e-09 7.014584000000e-06 1.063981000000e-09 7.014584000000e-06 1.066813000000e-09 7.014584000000e-06 1.069715000000e-09 7.014584000000e-06 1.073141000000e-09 7.014584000000e-06 1.075000000000e-09 7.014584000000e-06 1.075500000000e-09 -2.045237000000e-02 1.075834000000e-09 -3.390814000000e-02 1.076000000000e-09 -4.041766000000e-02 1.076266000000e-09 -3.909744000000e-02 1.076419000000e-09 -3.825815000000e-02 1.076822000000e-09 -3.580341000000e-02 1.078112000000e-09 -2.860957000000e-02 1.079915000000e-09 -2.078531000000e-02 1.082834000000e-09 -1.254042000000e-02 1.086452000000e-09 -6.730242000000e-03 1.089863000000e-09 -3.809885000000e-03 1.094093000000e-09 -1.921106000000e-03 1.097558000000e-09 -1.165292000000e-03 1.101264000000e-09 -7.066759000000e-04 1.105520000000e-09 -4.345162000000e-04 1.109056000000e-09 -2.960578000000e-04 1.112992000000e-09 -2.143280000000e-04 1.115807000000e-09 -1.668968000000e-04 1.118621000000e-09 -1.286359000000e-04 1.121942000000e-09 -1.072565000000e-04 1.125724000000e-09 -7.519642000000e-05 1.129501000000e-09 -6.307741000000e-05 1.133249000000e-09 -4.275253000000e-05 1.135809000000e-09 -3.578441000000e-05 1.138369000000e-09 -3.442614000000e-05 1.141791000000e-09 -2.275281000000e-05 1.145734000000e-09 -1.965626000000e-05 1.150017000000e-09 -1.004874000000e-05 1.153865000000e-09 -1.101774000000e-05 1.158361000000e-09 -4.752855000000e-06 1.161824000000e-09 -6.248524000000e-06 1.165535000000e-09 -1.369042000000e-06 1.169527000000e-09 -2.985060000000e-06 1.173109000000e-09 8.351501000000e-07 1.177056000000e-09 -9.222598000000e-07 1.179535000000e-09 1.221661000000e-07 1.182013000000e-09 2.823667000000e-06 1.185429000000e-09 9.678955000000e-07 1.189651000000e-09 3.466673000000e-06 1.193349000000e-09 2.248173000000e-06 1.197208000000e-09 4.168722000000e-06 1.200595000000e-09 2.921779000000e-06 1.204042000000e-09 4.361303000000e-06 1.207661000000e-09 3.396077000000e-06 1.212044000000e-09 4.802114000000e-06 1.215603000000e-09 4.004037000000e-06 1.219624000000e-09 5.070053000000e-06 1.222280000000e-09 5.063375000000e-06 1.224935000000e-09 4.491451000000e-06 1.228316000000e-09 5.342071000000e-06 1.229186000000e-09 5.240204000000e-06 1.230042000000e-09 5.197726000000e-06 1.232779000000e-09 6.109464000000e-06 1.235670000000e-09 6.044604000000e-06 1.238863000000e-09 6.017985000000e-06 1.243639000000e-09 5.932771000000e-06 1.246999000000e-09 5.994694000000e-06 1.250850000000e-09 5.922659000000e-06 1.255187000000e-09 5.993716000000e-06 1.258822000000e-09 5.927457000000e-06 1.259631000000e-09 5.958635000000e-06 1.260438000000e-09 5.963667000000e-06 1.263021000000e-09 5.963744000000e-06 1.265957000000e-09 5.966481000000e-06 1.269137000000e-09 5.964319000000e-06 1.273131000000e-09 5.967296000000e-06 1.276658000000e-09 5.965744000000e-06 1.280195000000e-09 5.968501000000e-06 1.284359000000e-09 5.967094000000e-06 1.288216000000e-09 5.969536000000e-06 1.291735000000e-09 5.968022000000e-06 1.292574000000e-09 5.968969000000e-06 1.293423000000e-09 5.969118000000e-06 1.296139000000e-09 5.969260000000e-06 1.299136000000e-09 5.969520000000e-06 1.302736000000e-09 5.969651000000e-06 1.306959000000e-09 5.969890000000e-06 1.310392000000e-09 5.969948000000e-06 1.314112000000e-09 5.970103000000e-06 1.317424000000e-09 5.970122000000e-06 1.320972000000e-09 5.970235000000e-06 1.324632000000e-09 5.970239000000e-06 1.327145000000e-09 5.970275000000e-06 1.329658000000e-09 5.970339000000e-06 1.333049000000e-09 5.970323000000e-06 1.337028000000e-09 5.970392000000e-06 1.341293000000e-09 5.970373000000e-06 1.345153000000e-09 5.970428000000e-06 1.349994000000e-09 5.970405000000e-06 1.353616000000e-09 5.970450000000e-06 1.357116000000e-09 5.970422000000e-06 1.357983000000e-09 5.970439000000e-06 1.358962000000e-09 5.970442000000e-06 1.362092000000e-09 5.970445000000e-06 1.364885000000e-09 5.970450000000e-06 1.369987000000e-09 5.970453000000e-06 1.373500000000e-09 5.970457000000e-06 1.377230000000e-09 5.970458000000e-06 1.381288000000e-09 5.970461000000e-06 1.384815000000e-09 5.970461000000e-06 1.388662000000e-09 5.970463000000e-06 1.389532000000e-09 5.970463000000e-06 1.390483000000e-09 5.970463000000e-06 1.393528000000e-09 5.970463000000e-06 1.396267000000e-09 5.970464000000e-06 1.399530000000e-09 5.970464000000e-06 1.403009000000e-09 5.970465000000e-06 1.406745000000e-09 5.970465000000e-06 1.410579000000e-09 5.970465000000e-06 1.413057000000e-09 5.970466000000e-06 1.415535000000e-09 5.970466000000e-06 1.418933000000e-09 5.970466000000e-06 1.419781000000e-09 5.970466000000e-06 1.420563000000e-09 5.970466000000e-06 1.423064000000e-09 5.970466000000e-06 1.426220000000e-09 5.970466000000e-06 1.429627000000e-09 5.970466000000e-06 1.432942000000e-09 5.970466000000e-06 1.436511000000e-09 5.970466000000e-06 1.439973000000e-09 5.970466000000e-06 1.444113000000e-09 5.970466000000e-06 1.447667000000e-09 5.970466000000e-06 1.448597000000e-09 5.970466000000e-06 1.449278000000e-09 5.970466000000e-06 1.451458000000e-09 5.970466000000e-06 1.454984000000e-09 5.970466000000e-06 1.458241000000e-09 5.970466000000e-06 1.461761000000e-09 5.970466000000e-06 1.465886000000e-09 5.970466000000e-06 1.469389000000e-09 5.970466000000e-06 1.472794000000e-09 5.970467000000e-06 1.475276000000e-09 5.970467000000e-06 1.477758000000e-09 5.970466000000e-06 1.479095000000e-09 5.970467000000e-06 1.479882000000e-09 5.970455000000e-06 1.482402000000e-09 5.970477000000e-06 1.485321000000e-09 5.970463000000e-06 1.488790000000e-09 5.970462000000e-06 1.492381000000e-09 5.970472000000e-06 1.496661000000e-09 5.970463000000e-06 1.500576000000e-09 5.970493000000e-06 1.504103000000e-09 5.970297000000e-06 1.508121000000e-09 5.970757000000e-06 1.509046000000e-09 5.970562000000e-06 1.509764000000e-09 5.970551000000e-06 1.512062000000e-09 5.970238000000e-06 1.514727000000e-09 5.970505000000e-06 1.518391000000e-09 5.970653000000e-06 1.521668000000e-09 5.974241000000e-06 1.525243000000e-09 5.957445000000e-06 1.529365000000e-09 5.981694000000e-06 1.532875000000e-09 5.971440000000e-06 1.534025000000e-09 5.966888000000e-06 1.534117000000e-09 -1.324049000000e-03 1.534180000000e-09 -2.242505000000e-03 1.534382000000e-09 -4.903910000000e-03 1.534737000000e-09 -8.711279000000e-03 1.535025000000e-09 -1.093889000000e-02 1.535086000000e-09 -1.048265000000e-02 1.535120000000e-09 -1.022476000000e-02 1.535227000000e-09 -9.444756000000e-03 1.535516000000e-09 -7.567934000000e-03 1.535770000000e-09 -6.175046000000e-03 1.536253000000e-09 -4.020092000000e-03 1.537797000000e-09 2.384812000000e-04 1.540037000000e-09 2.649914000000e-03 1.542991000000e-09 2.893956000000e-03 1.546340000000e-09 1.552666000000e-03 1.549563000000e-09 4.703692000000e-04 1.553023000000e-09 -1.483653000000e-04 1.556674000000e-09 -3.549543000000e-04 1.561332000000e-09 -2.911127000000e-04 1.564959000000e-09 -1.729025000000e-04 1.568637000000e-09 -9.519481000000e-05 1.572862000000e-09 -7.375262000000e-05 1.576410000000e-09 -9.261560000000e-05 1.580380000000e-09 -1.002460000000e-04 1.584817000000e-09 3.922719000000e-04 1.588226000000e-09 1.138569000000e-03 1.592181000000e-09 9.726414000000e-04 1.595925000000e-09 -3.405001000000e-03 1.599741000000e-09 -1.396987000000e-02 1.604581000000e-09 -1.601449000000e-02 1.606342000000e-09 -1.850211000000e-03 1.608103000000e-09 2.026723000000e-02 1.611836000000e-09 1.084575000000e-01 1.616035000000e-09 2.214266000000e-01 1.619218000000e-09 2.933188000000e-01 1.623182000000e-09 3.780300000000e-01 1.626358000000e-09 4.518070000000e-01 1.629985000000e-09 5.364395000000e-01 1.634074000000e-09 6.184660000000e-01 1.638238000000e-09 6.776563000000e-01 1.643068000000e-09 7.222162000000e-01 1.648476000000e-09 7.569729000000e-01 1.653917000000e-09 7.877439000000e-01 1.658595000000e-09 8.110706000000e-01 1.665047000000e-09 8.330518000000e-01 1.668427000000e-09 8.402630000000e-01 1.674362000000e-09 8.487051000000e-01 1.678501000000e-09 8.523089000000e-01 1.684581000000e-09 8.556780000000e-01 1.686093000000e-09 8.562030000000e-01 1.687486000000e-09 8.566610000000e-01 1.691945000000e-09 8.577979000000e-01 1.695547000000e-09 8.584232000000e-01 1.700342000000e-09 8.589912000000e-01 1.704014000000e-09 8.592804000000e-01 1.707642000000e-09 8.594837000000e-01 1.712914000000e-09 8.596812000000e-01 1.717024000000e-09 8.597791000000e-01 1.722796000000e-09 8.598668000000e-01 1.724262000000e-09 8.598813000000e-01 1.725743000000e-09 8.598949000000e-01 1.730482000000e-09 8.599281000000e-01 1.734128000000e-09 8.599452000000e-01 1.739613000000e-09 8.599623000000e-01 1.743241000000e-09 8.599695000000e-01 1.746998000000e-09 8.599748000000e-01 1.752400000000e-09 8.599798000000e-01 1.756586000000e-09 8.599822000000e-01 1.762468000000e-09 8.599844000000e-01 1.764025000000e-09 8.599848000000e-01 1.765380000000e-09 8.599851000000e-01 1.769719000000e-09 8.599858000000e-01 1.773264000000e-09 8.599862000000e-01 1.778028000000e-09 8.599866000000e-01 1.781718000000e-09 8.599868000000e-01 1.785310000000e-09 8.599870000000e-01 1.790811000000e-09 8.599871000000e-01 1.794844000000e-09 8.599872000000e-01 1.800637000000e-09 8.599872000000e-01 1.802097000000e-09 8.599872000000e-01 1.803580000000e-09 8.599873000000e-01 1.808326000000e-09 8.599873000000e-01 1.811970000000e-09 8.599873000000e-01 1.817496000000e-09 8.599873000000e-01 1.821120000000e-09 8.599873000000e-01 1.824884000000e-09 8.599873000000e-01 1.830308000000e-09 8.599873000000e-01 1.834495000000e-09 8.599873000000e-01 1.840377000000e-09 8.599873000000e-01 1.841939000000e-09 8.599873000000e-01 1.843284000000e-09 8.599873000000e-01 1.847586000000e-09 8.599873000000e-01 1.851115000000e-09 8.599873000000e-01 1.855851000000e-09 8.599873000000e-01 1.859543000000e-09 8.599873000000e-01 1.863125000000e-09 8.599873000000e-01 1.868621000000e-09 8.599873000000e-01 1.872640000000e-09 8.599873000000e-01 1.878406000000e-09 8.599873000000e-01 1.879857000000e-09 8.599873000000e-01 1.881342000000e-09 8.599873000000e-01 1.886097000000e-09 8.599873000000e-01 1.889729000000e-09 8.599873000000e-01 1.895406000000e-09 8.599873000000e-01 1.899019000000e-09 8.599873000000e-01 1.902802000000e-09 8.599873000000e-01 1.908327000000e-09 8.599873000000e-01 1.912510000000e-09 8.599873000000e-01 1.918396000000e-09 8.599873000000e-01 1.923452000000e-09 8.599873000000e-01 1.928319000000e-09 8.599873000000e-01 1.933832000000e-09 8.599873000000e-01 1.937865000000e-09 8.599873000000e-01 1.941516000000e-09 8.599873000000e-01 1.947123000000e-09 8.599873000000e-01 1.951206000000e-09 8.599873000000e-01 1.957151000000e-09 8.599873000000e-01 1.962202000000e-09 8.599873000000e-01 1.967100000000e-09 8.599873000000e-01 1.968013000000e-09 8.599873000000e-01 1.969099000000e-09 8.599873000000e-01 1.972453000000e-09 8.599873000000e-01 1.975701000000e-09 8.599873000000e-01 1.979195000000e-09 8.599873000000e-01 1.983866000000e-09 8.599873000000e-01 1.987814000000e-09 8.599873000000e-01 1.993099000000e-09 8.599873000000e-01 1.998488000000e-09 8.599873000000e-01 2.003935000000e-09 8.599873000000e-01 2.004866000000e-09 8.599873000000e-01 2.005730000000e-09 8.599873000000e-01 2.008495000000e-09 8.599873000000e-01 2.013208000000e-09 8.599873000000e-01 2.016501000000e-09 8.599873000000e-01 2.021215000000e-09 8.599873000000e-01 2.025252000000e-09 8.599873000000e-01 2.030301000000e-09 8.599873000000e-01 2.035760000000e-09 8.599873000000e-01 2.040977000000e-09 8.599873000000e-01 2.042009000000e-09 8.599873000000e-01 2.042812000000e-09 8.599873000000e-01 2.045379000000e-09 8.599873000000e-01 2.049639000000e-09 8.599873000000e-01 2.053254000000e-09 8.599873000000e-01 2.056728000000e-09 8.599873000000e-01 2.062152000000e-09 8.599873000000e-01 2.066039000000e-09 8.599873000000e-01 2.071558000000e-09 8.599873000000e-01 2.076872000000e-09 8.599873000000e-01 2.078300000000e-09 8.599873000000e-01 2.079144000000e-09 8.599873000000e-01 2.081843000000e-09 8.599873000000e-01 2.085459000000e-09 8.599873000000e-01 2.089564000000e-09 8.599873000000e-01 2.093109000000e-09 8.599873000000e-01 2.096789000000e-09 8.599877000000e-01 2.101106000000e-09 8.599879000000e-01 2.105378000000e-09 8.599873000000e-01 2.110838000000e-09 8.599866000000e-01 2.112251000000e-09 8.599865000000e-01 2.113753000000e-09 8.599861000000e-01 2.118558000000e-09 8.599836000000e-01 2.122133000000e-09 8.599830000000e-01 2.129360000000e-09 8.599806000000e-01 2.132821000000e-09 8.599811000000e-01 2.136929000000e-09 8.600317000000e-01 2.139763000000e-09 8.600748000000e-01 2.142597000000e-09 8.601247000000e-01 2.147012000000e-09 8.601365000000e-01 2.152765000000e-09 8.600137000000e-01 2.154377000000e-09 8.599099000000e-01 2.155442000000e-09 8.598230000000e-01 2.158852000000e-09 8.593556000000e-01 2.162621000000e-09 8.586972000000e-01 2.166944000000e-09 8.575427000000e-01 2.170618000000e-09 8.558768000000e-01 2.174167000000e-09 8.561227000000e-01 2.179170000000e-09 8.682731000000e-01 2.183292000000e-09 8.874853000000e-01 2.188867000000e-09 9.075992000000e-01 2.190278000000e-09 9.062251000000e-01 2.191779000000e-09 9.004780000000e-01 2.196584000000e-09 8.132372000000e-01 2.200169000000e-09 6.839902000000e-01 2.207050000000e-09 3.914829000000e-01 2.210543000000e-09 2.650777000000e-01 2.214570000000e-09 1.625633000000e-01 2.217383000000e-09 1.150300000000e-01 2.220196000000e-09 8.731206000000e-02 2.224548000000e-09 5.844941000000e-02 2.230327000000e-09 3.478215000000e-02 2.231668000000e-09 3.068359000000e-02 2.232487000000e-09 2.821894000000e-02 2.235108000000e-09 2.093856000000e-02 2.238430000000e-09 1.352901000000e-02 2.242101000000e-09 7.936321000000e-03 2.245250000000e-09 4.925416000000e-03 2.248623000000e-09 2.912430000000e-03 2.252399000000e-09 1.601060000000e-03 2.256336000000e-09 8.623049000000e-04 2.261919000000e-09 3.554516000000e-04 2.264384000000e-09 2.623914000000e-04 2.265883000000e-09 2.114733000000e-04 2.270679000000e-09 1.049887000000e-04 2.277378000000e-09 4.019896000000e-05 2.283984000000e-09 1.733820000000e-05 2.291963000000e-09 8.147573000000e-06 2.303337000000e-09 6.479547000000e-06 2.323042000000e-09 5.585946000000e-06 2.352076000000e-09 5.240744000000e-06 2.407975000000e-09 5.418306000000e-06 2.543499000000e-09 5.297086000000e-06 2.778736000000e-09 5.398903000000e-06 3.128736000000e-09 5.307537000000e-06 3.478736000000e-09 5.391191000000e-06 3.828736000000e-09 5.314734000000e-06 4.076000000000e-09 5.383185000000e-06 4.076500000000e-09 2.039184000000e-02 4.077000000000e-09 4.009347000000e-02 4.077306000000e-09 3.907114000000e-02 4.077515000000e-09 3.827336000000e-02 4.078112000000e-09 3.573185000000e-02 4.079900000000e-09 2.850805000000e-02 4.082540000000e-09 1.954129000000e-02 4.086501000000e-09 1.039249000000e-02 4.092049000000e-09 3.782886000000e-03 4.100074000000e-09 6.752157000000e-04 4.112222000000e-09 -3.185209000000e-05 4.128358000000e-09 2.215779000000e-05 4.151784000000e-09 -4.289509000000e-06 4.181738000000e-09 1.640455000000e-05 4.223091000000e-09 -1.079100000000e-06 4.287381000000e-09 1.501167000000e-05 4.412795000000e-09 -6.952056000000e-07 4.639879000000e-09 1.498042000000e-05 4.989879000000e-09 -1.112389000000e-06 5.339879000000e-09 1.534075000000e-05 5.689879000000e-09 -1.412463000000e-06 6.039879000000e-09 1.563265000000e-05 6.389879000000e-09 -1.712733000000e-06 6.739879000000e-09 1.588720000000e-05 7.000000000000e-09 -2.001502000000e-06)
V_XOR_29 xor_29 0 PWL(0.000000000000e+00 6.995220000000e-06 1.000000000000e-12 6.998010000000e-06 2.000000000000e-12 7.000531000000e-06 5.200000000000e-12 7.006882000000e-06 1.544000000000e-11 7.014230000000e-06 4.820800000000e-11 7.014563000000e-06 1.530656000000e-10 7.014614000000e-06 4.886099000000e-10 7.014551000000e-06 8.386099000000e-10 7.014617000000e-06 9.995000000000e-10 7.014549000000e-06 9.996500000000e-10 7.014553000000e-06 1.000130000000e-09 7.014560000000e-06 1.000271000000e-09 7.014562000000e-06 1.000500000000e-09 7.014565000000e-06 1.000549000000e-09 7.014565000000e-06 1.000579000000e-09 7.014566000000e-06 1.000674000000e-09 7.014567000000e-06 1.000921000000e-09 7.014568000000e-06 1.001177000000e-09 7.014570000000e-06 1.001636000000e-09 7.014572000000e-06 1.002995000000e-09 7.014577000000e-06 1.004717000000e-09 7.014580000000e-06 1.007157000000e-09 7.014583000000e-06 1.009530000000e-09 7.014585000000e-06 1.012064000000e-09 7.014586000000e-06 1.014479000000e-09 7.014587000000e-06 1.016999000000e-09 7.014587000000e-06 1.019780000000e-09 7.014586000000e-06 1.023006000000e-09 7.014586000000e-06 1.025715000000e-09 7.014586000000e-06 1.028767000000e-09 7.014585000000e-06 1.031545000000e-09 7.014585000000e-06 1.034548000000e-09 7.014585000000e-06 1.037295000000e-09 7.014584000000e-06 1.040188000000e-09 7.014584000000e-06 1.042931000000e-09 7.014584000000e-06 1.046095000000e-09 7.014584000000e-06 1.049020000000e-09 7.014584000000e-06 1.051920000000e-09 7.014584000000e-06 1.055268000000e-09 7.014584000000e-06 1.057963000000e-09 7.014584000000e-06 1.059420000000e-09 7.014584000000e-06 1.060877000000e-09 7.014584000000e-06 1.063981000000e-09 7.014584000000e-06 1.066813000000e-09 7.014584000000e-06 1.069715000000e-09 7.014584000000e-06 1.073141000000e-09 7.014584000000e-06 1.075000000000e-09 7.014584000000e-06 1.075500000000e-09 -2.015933000000e-02 1.075834000000e-09 -3.341368000000e-02 1.076000000000e-09 -3.981958000000e-02 1.076266000000e-09 -3.848219000000e-02 1.076419000000e-09 -3.763806000000e-02 1.076822000000e-09 -3.520220000000e-02 1.078112000000e-09 -2.822406000000e-02 1.079915000000e-09 -2.073186000000e-02 1.082834000000e-09 -1.270873000000e-02 1.086452000000e-09 -6.888620000000e-03 1.089863000000e-09 -3.913054000000e-03 1.094093000000e-09 -1.977172000000e-03 1.097558000000e-09 -1.197872000000e-03 1.101264000000e-09 -7.248007000000e-04 1.105520000000e-09 -4.433345000000e-04 1.109056000000e-09 -3.011952000000e-04 1.112992000000e-09 -2.166272000000e-04 1.115807000000e-09 -1.680255000000e-04 1.118621000000e-09 -1.293101000000e-04 1.121942000000e-09 -1.070611000000e-04 1.125724000000e-09 -7.601464000000e-05 1.129501000000e-09 -6.332235000000e-05 1.133249000000e-09 -4.301440000000e-05 1.135809000000e-09 -3.540870000000e-05 1.138369000000e-09 -3.288600000000e-05 1.141791000000e-09 -2.381707000000e-05 1.145734000000e-09 -2.127316000000e-05 1.150017000000e-09 -1.242672000000e-05 1.153865000000e-09 -1.205848000000e-05 1.158361000000e-09 -5.127186000000e-06 1.161824000000e-09 -6.394989000000e-06 1.165535000000e-09 -1.522351000000e-06 1.169527000000e-09 -2.939058000000e-06 1.173109000000e-09 7.653631000000e-07 1.177056000000e-09 -8.578207000000e-07 1.179535000000e-09 1.736180000000e-07 1.182013000000e-09 2.787089000000e-06 1.185429000000e-09 1.037117000000e-06 1.189651000000e-09 3.429760000000e-06 1.193349000000e-09 2.321809000000e-06 1.197208000000e-09 4.136077000000e-06 1.200595000000e-09 2.990546000000e-06 1.204042000000e-09 4.332937000000e-06 1.207661000000e-09 3.463741000000e-06 1.212044000000e-09 4.765377000000e-06 1.215603000000e-09 4.059822000000e-06 1.219624000000e-09 5.038337000000e-06 1.222280000000e-09 5.047299000000e-06 1.224935000000e-09 4.549416000000e-06 1.228316000000e-09 5.308622000000e-06 1.229186000000e-09 5.246122000000e-06 1.230042000000e-09 5.210452000000e-06 1.232779000000e-09 6.105985000000e-06 1.235670000000e-09 6.022844000000e-06 1.238863000000e-09 6.004989000000e-06 1.243639000000e-09 5.923432000000e-06 1.246999000000e-09 5.985819000000e-06 1.250850000000e-09 5.914435000000e-06 1.255187000000e-09 5.985894000000e-06 1.258822000000e-09 5.919790000000e-06 1.259631000000e-09 5.950981000000e-06 1.260438000000e-09 5.956154000000e-06 1.263021000000e-09 5.956207000000e-06 1.265957000000e-09 5.958814000000e-06 1.269137000000e-09 5.956673000000e-06 1.273131000000e-09 5.959733000000e-06 1.276658000000e-09 5.958214000000e-06 1.280195000000e-09 5.961000000000e-06 1.284359000000e-09 5.959595000000e-06 1.288216000000e-09 5.962053000000e-06 1.291735000000e-09 5.960530000000e-06 1.292574000000e-09 5.961483000000e-06 1.293423000000e-09 5.961633000000e-06 1.296139000000e-09 5.961775000000e-06 1.299136000000e-09 5.962036000000e-06 1.302736000000e-09 5.962168000000e-06 1.306959000000e-09 5.962407000000e-06 1.310392000000e-09 5.962465000000e-06 1.314112000000e-09 5.962620000000e-06 1.317424000000e-09 5.962640000000e-06 1.320972000000e-09 5.962752000000e-06 1.324632000000e-09 5.962756000000e-06 1.327145000000e-09 5.962792000000e-06 1.329658000000e-09 5.962857000000e-06 1.333049000000e-09 5.962840000000e-06 1.337028000000e-09 5.962910000000e-06 1.341293000000e-09 5.962890000000e-06 1.345153000000e-09 5.962946000000e-06 1.349994000000e-09 5.962922000000e-06 1.353616000000e-09 5.962968000000e-06 1.357116000000e-09 5.962939000000e-06 1.357983000000e-09 5.962957000000e-06 1.358962000000e-09 5.962960000000e-06 1.362092000000e-09 5.962963000000e-06 1.364885000000e-09 5.962967000000e-06 1.369987000000e-09 5.962971000000e-06 1.373500000000e-09 5.962974000000e-06 1.377230000000e-09 5.962975000000e-06 1.381288000000e-09 5.962978000000e-06 1.384815000000e-09 5.962978000000e-06 1.388662000000e-09 5.962980000000e-06 1.389532000000e-09 5.962980000000e-06 1.390483000000e-09 5.962980000000e-06 1.393528000000e-09 5.962981000000e-06 1.396267000000e-09 5.962981000000e-06 1.399530000000e-09 5.962982000000e-06 1.403009000000e-09 5.962982000000e-06 1.406745000000e-09 5.962983000000e-06 1.410579000000e-09 5.962983000000e-06 1.413057000000e-09 5.962983000000e-06 1.415535000000e-09 5.962983000000e-06 1.418933000000e-09 5.962983000000e-06 1.419781000000e-09 5.962983000000e-06 1.420563000000e-09 5.962983000000e-06 1.423064000000e-09 5.962983000000e-06 1.426220000000e-09 5.962983000000e-06 1.429627000000e-09 5.962984000000e-06 1.432942000000e-09 5.962984000000e-06 1.436511000000e-09 5.962984000000e-06 1.439973000000e-09 5.962984000000e-06 1.444113000000e-09 5.962984000000e-06 1.447667000000e-09 5.962984000000e-06 1.448597000000e-09 5.962984000000e-06 1.449278000000e-09 5.962984000000e-06 1.451458000000e-09 5.962984000000e-06 1.454984000000e-09 5.962984000000e-06 1.458241000000e-09 5.962984000000e-06 1.461761000000e-09 5.962984000000e-06 1.465886000000e-09 5.962984000000e-06 1.469389000000e-09 5.962984000000e-06 1.472794000000e-09 5.962984000000e-06 1.475276000000e-09 5.962984000000e-06 1.477758000000e-09 5.962984000000e-06 1.479095000000e-09 5.962984000000e-06 1.479882000000e-09 5.962984000000e-06 1.482402000000e-09 5.962984000000e-06 1.485321000000e-09 5.962984000000e-06 1.488790000000e-09 5.962984000000e-06 1.492381000000e-09 5.962984000000e-06 1.496661000000e-09 5.962984000000e-06 1.500576000000e-09 5.962984000000e-06 1.504103000000e-09 5.962981000000e-06 1.508121000000e-09 5.962991000000e-06 1.509046000000e-09 5.962983000000e-06 1.509764000000e-09 5.962982000000e-06 1.512062000000e-09 5.962979000000e-06 1.514727000000e-09 5.962988000000e-06 1.518391000000e-09 5.962985000000e-06 1.521668000000e-09 5.963027000000e-06 1.525243000000e-09 5.962758000000e-06 1.529365000000e-09 5.963393000000e-06 1.532875000000e-09 5.962678000000e-06 1.534025000000e-09 5.962783000000e-06 1.534117000000e-09 -1.333189000000e-03 1.534180000000e-09 -2.256253000000e-03 1.534382000000e-09 -4.924512000000e-03 1.534737000000e-09 -8.738767000000e-03 1.535025000000e-09 -1.096535000000e-02 1.535086000000e-09 -1.050546000000e-02 1.535120000000e-09 -1.024535000000e-02 1.535227000000e-09 -9.458153000000e-03 1.535516000000e-09 -7.566694000000e-03 1.535770000000e-09 -6.165429000000e-03 1.536253000000e-09 -4.003239000000e-03 1.537797000000e-09 2.536970000000e-04 1.540037000000e-09 2.649989000000e-03 1.542991000000e-09 2.889449000000e-03 1.546340000000e-09 1.551436000000e-03 1.549563000000e-09 4.723937000000e-04 1.553023000000e-09 -1.465429000000e-04 1.556674000000e-09 -3.545010000000e-04 1.561332000000e-09 -2.924153000000e-04 1.564959000000e-09 -1.788256000000e-04 1.568637000000e-09 -9.778857000000e-05 1.572862000000e-09 -4.707882000000e-05 1.576410000000e-09 -2.435142000000e-05 1.580380000000e-09 -7.303382000000e-06 1.584817000000e-09 1.030891000000e-05 1.588226000000e-09 1.364182000000e-05 1.592181000000e-09 -5.269257000000e-06 1.595925000000e-09 -5.095289000000e-05 1.599741000000e-09 -1.129817000000e-04 1.604581000000e-09 2.296686000000e-04 1.606342000000e-09 6.036237000000e-04 1.608103000000e-09 1.110580000000e-03 1.611836000000e-09 1.226673000000e-03 1.616035000000e-09 -6.049129000000e-03 1.619218000000e-09 -1.845927000000e-02 1.623182000000e-09 -1.787867000000e-02 1.626358000000e-09 2.218960000000e-02 1.629985000000e-09 1.143529000000e-01 1.634074000000e-09 2.258008000000e-01 1.638238000000e-09 3.190742000000e-01 1.643068000000e-09 4.251633000000e-01 1.648476000000e-09 5.506831000000e-01 1.653917000000e-09 6.505612000000e-01 1.658595000000e-09 7.036357000000e-01 1.665047000000e-09 7.501204000000e-01 1.668427000000e-09 7.692928000000e-01 1.674362000000e-09 8.016118000000e-01 1.678501000000e-09 8.197192000000e-01 1.684581000000e-09 8.371139000000e-01 1.686093000000e-09 8.398937000000e-01 1.687486000000e-09 8.423065000000e-01 1.691945000000e-09 8.483169000000e-01 1.695547000000e-09 8.516370000000e-01 1.700342000000e-09 8.546625000000e-01 1.704014000000e-09 8.562064000000e-01 1.707642000000e-09 8.572931000000e-01 1.712914000000e-09 8.583493000000e-01 1.717024000000e-09 8.588731000000e-01 1.722796000000e-09 8.593428000000e-01 1.724262000000e-09 8.594200000000e-01 1.725743000000e-09 8.594928000000e-01 1.730482000000e-09 8.596708000000e-01 1.734128000000e-09 8.597623000000e-01 1.739613000000e-09 8.598534000000e-01 1.743241000000e-09 8.598920000000e-01 1.746998000000e-09 8.599202000000e-01 1.752400000000e-09 8.599471000000e-01 1.756586000000e-09 8.599602000000e-01 1.762468000000e-09 8.599718000000e-01 1.764025000000e-09 8.599737000000e-01 1.765380000000e-09 8.599753000000e-01 1.769719000000e-09 8.599794000000e-01 1.773264000000e-09 8.599816000000e-01 1.778028000000e-09 8.599837000000e-01 1.781718000000e-09 8.599847000000e-01 1.785310000000e-09 8.599855000000e-01 1.790811000000e-09 8.599862000000e-01 1.794844000000e-09 8.599866000000e-01 1.800637000000e-09 8.599869000000e-01 1.802097000000e-09 8.599869000000e-01 1.803580000000e-09 8.599870000000e-01 1.808326000000e-09 8.599871000000e-01 1.811970000000e-09 8.599872000000e-01 1.817496000000e-09 8.599872000000e-01 1.821120000000e-09 8.599873000000e-01 1.824884000000e-09 8.599873000000e-01 1.830308000000e-09 8.599873000000e-01 1.834495000000e-09 8.599873000000e-01 1.840377000000e-09 8.599873000000e-01 1.841939000000e-09 8.599873000000e-01 1.843284000000e-09 8.599873000000e-01 1.847586000000e-09 8.599873000000e-01 1.851115000000e-09 8.599873000000e-01 1.855851000000e-09 8.599873000000e-01 1.859543000000e-09 8.599873000000e-01 1.863125000000e-09 8.599873000000e-01 1.868621000000e-09 8.599873000000e-01 1.872640000000e-09 8.599873000000e-01 1.878406000000e-09 8.599873000000e-01 1.879857000000e-09 8.599873000000e-01 1.881342000000e-09 8.599873000000e-01 1.886097000000e-09 8.599873000000e-01 1.889729000000e-09 8.599873000000e-01 1.895406000000e-09 8.599873000000e-01 1.899019000000e-09 8.599873000000e-01 1.902802000000e-09 8.599873000000e-01 1.908327000000e-09 8.599873000000e-01 1.912510000000e-09 8.599873000000e-01 1.918396000000e-09 8.599873000000e-01 1.923452000000e-09 8.599873000000e-01 1.928319000000e-09 8.599873000000e-01 1.933832000000e-09 8.599873000000e-01 1.937865000000e-09 8.599873000000e-01 1.941516000000e-09 8.599873000000e-01 1.947123000000e-09 8.599873000000e-01 1.951206000000e-09 8.599873000000e-01 1.957151000000e-09 8.599873000000e-01 1.962202000000e-09 8.599873000000e-01 1.967100000000e-09 8.599873000000e-01 1.968013000000e-09 8.599873000000e-01 1.969099000000e-09 8.599873000000e-01 1.972453000000e-09 8.599873000000e-01 1.975701000000e-09 8.599873000000e-01 1.979195000000e-09 8.599873000000e-01 1.983866000000e-09 8.599873000000e-01 1.987814000000e-09 8.599873000000e-01 1.993099000000e-09 8.599873000000e-01 1.998488000000e-09 8.599873000000e-01 2.003935000000e-09 8.599873000000e-01 2.004866000000e-09 8.599873000000e-01 2.005730000000e-09 8.599873000000e-01 2.008495000000e-09 8.599873000000e-01 2.013208000000e-09 8.599873000000e-01 2.016501000000e-09 8.599873000000e-01 2.021215000000e-09 8.599873000000e-01 2.025252000000e-09 8.599873000000e-01 2.030301000000e-09 8.599873000000e-01 2.035760000000e-09 8.599873000000e-01 2.040977000000e-09 8.599873000000e-01 2.042009000000e-09 8.599873000000e-01 2.042812000000e-09 8.599873000000e-01 2.045379000000e-09 8.599873000000e-01 2.049639000000e-09 8.599873000000e-01 2.053254000000e-09 8.599873000000e-01 2.056728000000e-09 8.599873000000e-01 2.062152000000e-09 8.599873000000e-01 2.066039000000e-09 8.599873000000e-01 2.071558000000e-09 8.599873000000e-01 2.076872000000e-09 8.599873000000e-01 2.078300000000e-09 8.599873000000e-01 2.079144000000e-09 8.599873000000e-01 2.081843000000e-09 8.599873000000e-01 2.085459000000e-09 8.599873000000e-01 2.089564000000e-09 8.599873000000e-01 2.093109000000e-09 8.599873000000e-01 2.096789000000e-09 8.599873000000e-01 2.101106000000e-09 8.599873000000e-01 2.105378000000e-09 8.599873000000e-01 2.110838000000e-09 8.599873000000e-01 2.112251000000e-09 8.599873000000e-01 2.113753000000e-09 8.599873000000e-01 2.118558000000e-09 8.599873000000e-01 2.122133000000e-09 8.599873000000e-01 2.129360000000e-09 8.599873000000e-01 2.132821000000e-09 8.599873000000e-01 2.136929000000e-09 8.599878000000e-01 2.139763000000e-09 8.599879000000e-01 2.142597000000e-09 8.599877000000e-01 2.147012000000e-09 8.599868000000e-01 2.152765000000e-09 8.599861000000e-01 2.154377000000e-09 8.599856000000e-01 2.155442000000e-09 8.599850000000e-01 2.158852000000e-09 8.599827000000e-01 2.162621000000e-09 8.599833000000e-01 2.166944000000e-09 8.599815000000e-01 2.170618000000e-09 8.599769000000e-01 2.174167000000e-09 8.600054000000e-01 2.179170000000e-09 8.601014000000e-01 2.183292000000e-09 8.601442000000e-01 2.188867000000e-09 8.601075000000e-01 2.190278000000e-09 8.600740000000e-01 2.191779000000e-09 8.600091000000e-01 2.196584000000e-09 8.594701000000e-01 2.200169000000e-09 8.588460000000e-01 2.207050000000e-09 8.565705000000e-01 2.210543000000e-09 8.547320000000e-01 2.214570000000e-09 8.579880000000e-01 2.217383000000e-09 8.668920000000e-01 2.220196000000e-09 8.812490000000e-01 2.224548000000e-09 9.061061000000e-01 2.230327000000e-09 8.815961000000e-01 2.231668000000e-09 8.517714000000e-01 2.232487000000e-09 8.306966000000e-01 2.235108000000e-09 7.396460000000e-01 2.238430000000e-09 5.889774000000e-01 2.242101000000e-09 4.129369000000e-01 2.245250000000e-09 2.870398000000e-01 2.248623000000e-09 1.861435000000e-01 2.252399000000e-09 1.173375000000e-01 2.256336000000e-09 7.753733000000e-02 2.261919000000e-09 4.575497000000e-02 2.264384000000e-09 3.759598000000e-02 2.265883000000e-09 3.288360000000e-02 2.270679000000e-09 1.941150000000e-02 2.277378000000e-09 7.176250000000e-03 2.283984000000e-09 2.274304000000e-03 2.291963000000e-09 5.294290000000e-04 2.303337000000e-09 5.131082000000e-05 2.323042000000e-09 -3.976861000000e-06 2.352076000000e-09 1.041644000000e-05 2.407975000000e-09 6.553133000000e-06 2.543499000000e-09 6.699443000000e-06 2.778736000000e-09 6.823061000000e-06 3.128736000000e-09 6.467558000000e-06 3.478736000000e-09 6.927018000000e-06 3.828736000000e-09 6.353964000000e-06 4.076000000000e-09 7.060693000000e-06 4.076500000000e-09 2.067457000000e-02 4.077000000000e-09 4.069948000000e-02 4.077306000000e-09 3.971790000000e-02 4.077515000000e-09 3.893723000000e-02 4.078112000000e-09 3.640150000000e-02 4.079900000000e-09 2.900874000000e-02 4.082540000000e-09 1.962271000000e-02 4.086501000000e-09 1.009363000000e-02 4.092049000000e-09 3.461873000000e-03 4.100074000000e-09 5.503541000000e-04 4.112222000000e-09 -3.436808000000e-05 4.128358000000e-09 2.353488000000e-05 4.151784000000e-09 -4.127552000000e-06 4.181738000000e-09 1.655813000000e-05 4.223091000000e-09 -2.212096000000e-07 4.287381000000e-09 1.491669000000e-05 4.412795000000e-09 1.650059000000e-07 4.639879000000e-09 1.474933000000e-05 4.989879000000e-09 -2.577640000000e-07 5.339879000000e-09 1.519171000000e-05 5.689879000000e-09 -6.081853000000e-07 6.039879000000e-09 1.557055000000e-05 6.389879000000e-09 -9.620509000000e-07 6.739879000000e-09 1.591260000000e-05 7.000000000000e-09 -1.313229000000e-06)
E_SAFE_D_00 safe_d_r_00 0 safe_d_0 0 8.636363636364e-01
E_SAFE_D_01 safe_d_r_01 0 safe_d_1 0 8.636363636364e-01
E_SAFE_D_02 safe_d_r_02 0 safe_d_2 0 8.636363636364e-01
E_SAFE_D_03 safe_d_r_03 0 safe_d_3 0 8.636363636364e-01
E_SAFE_D_04 safe_d_r_04 0 safe_d_4 0 8.636363636364e-01
E_SAFE_D_05 safe_d_r_05 0 safe_d_5 0 8.636363636364e-01
E_SAFE_D_06 safe_d_r_06 0 safe_d_6 0 8.636363636364e-01
E_SAFE_D_07 safe_d_r_07 0 safe_d_7 0 8.636363636364e-01
E_SAFE_D_08 safe_d_r_08 0 safe_d_8 0 8.636363636364e-01
E_SAFE_D_09 safe_d_r_09 0 safe_d_9 0 8.636363636364e-01
E_SAFE_D_10 safe_d_r_10 0 safe_d_10 0 8.636363636364e-01
E_SAFE_D_11 safe_d_r_11 0 safe_d_11 0 8.636363636364e-01
E_SAFE_D_12 safe_d_r_12 0 safe_d_12 0 8.636363636364e-01
E_SAFE_D_13 safe_d_r_13 0 safe_d_13 0 8.636363636364e-01
E_SAFE_D_14 safe_d_r_14 0 safe_d_14 0 8.636363636364e-01
E_SAFE_D_15 safe_d_r_15 0 safe_d_15 0 8.636363636364e-01
E_SAFE_D_16 safe_d_r_16 0 safe_d_16 0 8.636363636364e-01
E_SAFE_D_17 safe_d_r_17 0 safe_d_17 0 8.636363636364e-01
E_SAFE_D_18 safe_d_r_18 0 safe_d_18 0 8.636363636364e-01
E_SAFE_D_19 safe_d_r_19 0 safe_d_19 0 8.636363636364e-01
E_SAFE_D_20 safe_d_r_20 0 safe_d_20 0 8.636363636364e-01
E_SAFE_D_21 safe_d_r_21 0 safe_d_21 0 8.636363636364e-01
E_SAFE_D_22 safe_d_r_22 0 safe_d_22 0 8.636363636364e-01
E_SAFE_D_23 safe_d_r_23 0 safe_d_23 0 8.636363636364e-01
E_SAFE_D_24 safe_d_r_24 0 safe_d_24 0 8.636363636364e-01
E_SAFE_D_25 safe_d_r_25 0 safe_d_25 0 8.636363636364e-01
E_SAFE_D_26 safe_d_r_26 0 safe_d_26 0 8.636363636364e-01
E_SAFE_D_27 safe_d_r_27 0 safe_d_27 0 8.636363636364e-01
E_SAFE_D_28 safe_d_r_28 0 safe_d_28 0 8.636363636364e-01
E_SAFE_D_29 safe_d_r_29 0 safe_d_29 0 8.636363636364e-01
E_LATCH_G latch_g_r 0 latch_g 0 0.999999999999
* LATQ positional order: Q VDD VNW VPW VSS D G.
XLATCH_00 q_00 vdd_safe vdd_safe vss_safe vss_safe safe_d_r_00 latch_g_r LATQ_X0P5M_A9TR40
XLATCH_01 q_01 vdd_safe vdd_safe vss_safe vss_safe safe_d_r_01 latch_g_r LATQ_X0P5M_A9TR40
XLATCH_02 q_02 vdd_safe vdd_safe vss_safe vss_safe safe_d_r_02 latch_g_r LATQ_X0P5M_A9TR40
XLATCH_03 q_03 vdd_safe vdd_safe vss_safe vss_safe safe_d_r_03 latch_g_r LATQ_X0P5M_A9TR40
XLATCH_04 q_04 vdd_safe vdd_safe vss_safe vss_safe safe_d_r_04 latch_g_r LATQ_X0P5M_A9TR40
XLATCH_05 q_05 vdd_safe vdd_safe vss_safe vss_safe safe_d_r_05 latch_g_r LATQ_X0P5M_A9TR40
XLATCH_06 q_06 vdd_safe vdd_safe vss_safe vss_safe safe_d_r_06 latch_g_r LATQ_X0P5M_A9TR40
XLATCH_07 q_07 vdd_safe vdd_safe vss_safe vss_safe safe_d_r_07 latch_g_r LATQ_X0P5M_A9TR40
XLATCH_08 q_08 vdd_safe vdd_safe vss_safe vss_safe safe_d_r_08 latch_g_r LATQ_X0P5M_A9TR40
XLATCH_09 q_09 vdd_safe vdd_safe vss_safe vss_safe safe_d_r_09 latch_g_r LATQ_X0P5M_A9TR40
XLATCH_10 q_10 vdd_safe vdd_safe vss_safe vss_safe safe_d_r_10 latch_g_r LATQ_X0P5M_A9TR40
XLATCH_11 q_11 vdd_safe vdd_safe vss_safe vss_safe safe_d_r_11 latch_g_r LATQ_X0P5M_A9TR40
XLATCH_12 q_12 vdd_safe vdd_safe vss_safe vss_safe safe_d_r_12 latch_g_r LATQ_X0P5M_A9TR40
XLATCH_13 q_13 vdd_safe vdd_safe vss_safe vss_safe safe_d_r_13 latch_g_r LATQ_X0P5M_A9TR40
XLATCH_14 q_14 vdd_safe vdd_safe vss_safe vss_safe safe_d_r_14 latch_g_r LATQ_X0P5M_A9TR40
XLATCH_15 q_15 vdd_safe vdd_safe vss_safe vss_safe safe_d_r_15 latch_g_r LATQ_X0P5M_A9TR40
XLATCH_16 q_16 vdd_safe vdd_safe vss_safe vss_safe safe_d_r_16 latch_g_r LATQ_X0P5M_A9TR40
XLATCH_17 q_17 vdd_safe vdd_safe vss_safe vss_safe safe_d_r_17 latch_g_r LATQ_X0P5M_A9TR40
XLATCH_18 q_18 vdd_safe vdd_safe vss_safe vss_safe safe_d_r_18 latch_g_r LATQ_X0P5M_A9TR40
XLATCH_19 q_19 vdd_safe vdd_safe vss_safe vss_safe safe_d_r_19 latch_g_r LATQ_X0P5M_A9TR40
XLATCH_20 q_20 vdd_safe vdd_safe vss_safe vss_safe safe_d_r_20 latch_g_r LATQ_X0P5M_A9TR40
XLATCH_21 q_21 vdd_safe vdd_safe vss_safe vss_safe safe_d_r_21 latch_g_r LATQ_X0P5M_A9TR40
XLATCH_22 q_22 vdd_safe vdd_safe vss_safe vss_safe safe_d_r_22 latch_g_r LATQ_X0P5M_A9TR40
XLATCH_23 q_23 vdd_safe vdd_safe vss_safe vss_safe safe_d_r_23 latch_g_r LATQ_X0P5M_A9TR40
XLATCH_24 q_24 vdd_safe vdd_safe vss_safe vss_safe safe_d_r_24 latch_g_r LATQ_X0P5M_A9TR40
XLATCH_25 q_25 vdd_safe vdd_safe vss_safe vss_safe safe_d_r_25 latch_g_r LATQ_X0P5M_A9TR40
XLATCH_26 q_26 vdd_safe vdd_safe vss_safe vss_safe safe_d_r_26 latch_g_r LATQ_X0P5M_A9TR40
XLATCH_27 q_27 vdd_safe vdd_safe vss_safe vss_safe safe_d_r_27 latch_g_r LATQ_X0P5M_A9TR40
XLATCH_28 q_28 vdd_safe vdd_safe vss_safe vss_safe safe_d_r_28 latch_g_r LATQ_X0P5M_A9TR40
XLATCH_29 q_29 vdd_safe vdd_safe vss_safe vss_safe safe_d_r_29 latch_g_r LATQ_X0P5M_A9TR40
* Probe every required analog boundary and every latch output.
.probe tran v(vdd_sense) v(vdd_safe) v(latch_g_r) v(xor_00) v(xor_01) v(xor_02) v(xor_03) v(xor_04) v(xor_05) v(xor_06) v(xor_07) v(xor_08) v(xor_09) v(xor_10) v(xor_11) v(xor_12) v(xor_13) v(xor_14) v(xor_15) v(xor_16) v(xor_17) v(xor_18) v(xor_19) v(xor_20) v(xor_21) v(xor_22) v(xor_23) v(xor_24) v(xor_25) v(xor_26) v(xor_27) v(xor_28) v(xor_29) v(safe_d_r_00) v(safe_d_r_01) v(safe_d_r_02) v(safe_d_r_03) v(safe_d_r_04) v(safe_d_r_05) v(safe_d_r_06) v(safe_d_r_07) v(safe_d_r_08) v(safe_d_r_09) v(safe_d_r_10) v(safe_d_r_11) v(safe_d_r_12) v(safe_d_r_13) v(safe_d_r_14) v(safe_d_r_15) v(safe_d_r_16) v(safe_d_r_17) v(safe_d_r_18) v(safe_d_r_19) v(safe_d_r_20) v(safe_d_r_21) v(safe_d_r_22) v(safe_d_r_23) v(safe_d_r_24) v(safe_d_r_25) v(safe_d_r_26) v(safe_d_r_27) v(safe_d_r_28) v(safe_d_r_29) v(q_00) v(q_01) v(q_02) v(q_03) v(q_04) v(q_05) v(q_06) v(q_07) v(q_08) v(q_09) v(q_10) v(q_11) v(q_12) v(q_13) v(q_14) v(q_15) v(q_16) v(q_17) v(q_18) v(q_19) v(q_20) v(q_21) v(q_22) v(q_23) v(q_24) v(q_25) v(q_26) v(q_27) v(q_28) v(q_29)
.tran 1p 7.000000000000e-09
.ENDS bfe2_l1a_ams
