* Frozen sensor subcircuit extracted from exact-path acceptance.
.SUBCKT FTC_SENSOR Q_FINAL S_SCLK S_RESET M15 M14 M13 M12 M11 M10 M9 M8 M7 M6 M5 M4 M3 M2 M1 M0 F9 F8 F7 F6 F5 F4 F3 F2 F1 F0 VDD VSS
XRVT_INIT_00 rvt_initial_0 VDD VDD VSS VSS S_SCLK BUF_X0P7M_A9TR40
XRVT_INIT_01 rvt_initial_1 VDD VDD VSS VSS rvt_initial_0 BUF_X0P7M_A9TR40
XRVT_INIT_02 rvt_initial_2 VDD VDD VSS VSS rvt_initial_1 BUF_X0P7M_A9TR40
XRVT_INIT_03 rvt_initial_3 VDD VDD VSS VSS rvt_initial_2 BUF_X0P7M_A9TR40
XRVT_00 rvt_0 VDD VDD VSS VSS rvt_initial_3 BUF_X0P7M_A9TR40
XRVT_01 rvt_1 VDD VDD VSS VSS rvt_0 BUF_X0P7M_A9TR40
XRVT_02 rvt_2 VDD VDD VSS VSS rvt_1 BUF_X0P7M_A9TR40
XRVT_03 rvt_3 VDD VDD VSS VSS rvt_2 BUF_X0P7M_A9TR40
XRVT_04 rvt_4 VDD VDD VSS VSS rvt_3 BUF_X0P7M_A9TR40
XRVT_05 rvt_5 VDD VDD VSS VSS rvt_4 BUF_X0P7M_A9TR40
XRVT_06 rvt_6 VDD VDD VSS VSS rvt_5 BUF_X0P7M_A9TR40
XRVT_07 rvt_7 VDD VDD VSS VSS rvt_6 BUF_X0P7M_A9TR40
XRVT_08 rvt_8 VDD VDD VSS VSS rvt_7 BUF_X0P7M_A9TR40
XRVT_09 rvt_9 VDD VDD VSS VSS rvt_8 BUF_X0P7M_A9TR40
XRVT_10 rvt_10 VDD VDD VSS VSS rvt_9 BUF_X0P7M_A9TR40
XRVT_11 rvt_11 VDD VDD VSS VSS rvt_10 BUF_X0P7M_A9TR40
XRVT_12 rvt_12 VDD VDD VSS VSS rvt_11 BUF_X0P7M_A9TR40
XRVT_13 rvt_13 VDD VDD VSS VSS rvt_12 BUF_X0P7M_A9TR40
XRVT_14 rvt_14 VDD VDD VSS VSS rvt_13 BUF_X0P7M_A9TR40
XRVT_15 rvt_15 VDD VDD VSS VSS rvt_14 BUF_X0P7M_A9TR40
XRVT_16 rvt_16 VDD VDD VSS VSS rvt_15 BUF_X0P7M_A9TR40
XRVT_17 rvt_17 VDD VDD VSS VSS rvt_16 BUF_X0P7M_A9TR40
XRVT_18 rvt_18 VDD VDD VSS VSS rvt_17 BUF_X0P7M_A9TR40
XRVT_19 rvt_19 VDD VDD VSS VSS rvt_18 BUF_X0P7M_A9TR40
XRVT_20 rvt_20 VDD VDD VSS VSS rvt_19 BUF_X0P7M_A9TR40
XRVT_21 rvt_21 VDD VDD VSS VSS rvt_20 BUF_X0P7M_A9TR40
XRVT_22 rvt_22 VDD VDD VSS VSS rvt_21 BUF_X0P7M_A9TR40
XRVT_23 rvt_23 VDD VDD VSS VSS rvt_22 BUF_X0P7M_A9TR40
XRVT_24 rvt_24 VDD VDD VSS VSS rvt_23 BUF_X0P7M_A9TR40
XRVT_25 rvt_25 VDD VDD VSS VSS rvt_24 BUF_X0P7M_A9TR40
XRVT_26 rvt_26 VDD VDD VSS VSS rvt_25 BUF_X0P7M_A9TR40
XRVT_27 rvt_27 VDD VDD VSS VSS rvt_26 BUF_X0P7M_A9TR40
XRVT_28 rvt_28 VDD VDD VSS VSS rvt_27 BUF_X0P7M_A9TR40
XRVT_29 rvt_29 VDD VDD VSS VSS rvt_28 BUF_X0P7M_A9TR40
XLVT_00 lvt_0 VDD VDD VSS VSS S_SCLK BUF_X0P7M_A9TL40
XLVT_01 lvt_1 VDD VDD VSS VSS lvt_0 BUF_X0P7M_A9TL40
XLVT_02 lvt_2 VDD VDD VSS VSS lvt_1 BUF_X0P7M_A9TL40
XLVT_03 lvt_3 VDD VDD VSS VSS lvt_2 BUF_X0P7M_A9TL40
XLVT_04 lvt_4 VDD VDD VSS VSS lvt_3 BUF_X0P7M_A9TL40
XLVT_05 lvt_5 VDD VDD VSS VSS lvt_4 BUF_X0P7M_A9TL40
XLVT_06 lvt_6 VDD VDD VSS VSS lvt_5 BUF_X0P7M_A9TL40
XLVT_07 lvt_7 VDD VDD VSS VSS lvt_6 BUF_X0P7M_A9TL40
XLVT_08 lvt_8 VDD VDD VSS VSS lvt_7 BUF_X0P7M_A9TL40
XLVT_09 lvt_9 VDD VDD VSS VSS lvt_8 BUF_X0P7M_A9TL40
XLVT_10 lvt_10 VDD VDD VSS VSS lvt_9 BUF_X0P7M_A9TL40
XLVT_11 lvt_11 VDD VDD VSS VSS lvt_10 BUF_X0P7M_A9TL40
XLVT_12 lvt_12 VDD VDD VSS VSS lvt_11 BUF_X0P7M_A9TL40
XLVT_13 lvt_13 VDD VDD VSS VSS lvt_12 BUF_X0P7M_A9TL40
XLVT_14 lvt_14 VDD VDD VSS VSS lvt_13 BUF_X0P7M_A9TL40
XLVT_15 lvt_15 VDD VDD VSS VSS lvt_14 BUF_X0P7M_A9TL40
XLVT_16 lvt_16 VDD VDD VSS VSS lvt_15 BUF_X0P7M_A9TL40
XLVT_17 lvt_17 VDD VDD VSS VSS lvt_16 BUF_X0P7M_A9TL40
XLVT_18 lvt_18 VDD VDD VSS VSS lvt_17 BUF_X0P7M_A9TL40
XLVT_19 lvt_19 VDD VDD VSS VSS lvt_18 BUF_X0P7M_A9TL40
XLVT_20 lvt_20 VDD VDD VSS VSS lvt_19 BUF_X0P7M_A9TL40
XLVT_21 lvt_21 VDD VDD VSS VSS lvt_20 BUF_X0P7M_A9TL40
XLVT_22 lvt_22 VDD VDD VSS VSS lvt_21 BUF_X0P7M_A9TL40
XLVT_23 lvt_23 VDD VDD VSS VSS lvt_22 BUF_X0P7M_A9TL40
XLVT_24 lvt_24 VDD VDD VSS VSS lvt_23 BUF_X0P7M_A9TL40
XLVT_25 lvt_25 VDD VDD VSS VSS lvt_24 BUF_X0P7M_A9TL40
XLVT_26 lvt_26 VDD VDD VSS VSS lvt_25 BUF_X0P7M_A9TL40
XLVT_27 lvt_27 VDD VDD VSS VSS lvt_26 BUF_X0P7M_A9TL40
XLVT_28 lvt_28 VDD VDD VSS VSS lvt_27 BUF_X0P7M_A9TL40
XLVT_29 lvt_29 VDD VDD VSS VSS lvt_28 BUF_X0P7M_A9TL40
XXOR_00 xor_0 VDD VDD VSS VSS rvt_0 lvt_0 XOR2_X0P5M_A9TR40
XXOR_01 xor_1 VDD VDD VSS VSS rvt_1 lvt_1 XOR2_X0P5M_A9TR40
XXOR_02 xor_2 VDD VDD VSS VSS rvt_2 lvt_2 XOR2_X0P5M_A9TR40
XXOR_03 xor_3 VDD VDD VSS VSS rvt_3 lvt_3 XOR2_X0P5M_A9TR40
XXOR_04 xor_4 VDD VDD VSS VSS rvt_4 lvt_4 XOR2_X0P5M_A9TR40
XXOR_05 xor_5 VDD VDD VSS VSS rvt_5 lvt_5 XOR2_X0P5M_A9TR40
XXOR_06 xor_6 VDD VDD VSS VSS rvt_6 lvt_6 XOR2_X0P5M_A9TR40
XXOR_07 xor_7 VDD VDD VSS VSS rvt_7 lvt_7 XOR2_X0P5M_A9TR40
XXOR_08 xor_8 VDD VDD VSS VSS rvt_8 lvt_8 XOR2_X0P5M_A9TR40
XXOR_09 xor_9 VDD VDD VSS VSS rvt_9 lvt_9 XOR2_X0P5M_A9TR40
XXOR_10 xor_10 VDD VDD VSS VSS rvt_10 lvt_10 XOR2_X0P5M_A9TR40
XXOR_11 xor_11 VDD VDD VSS VSS rvt_11 lvt_11 XOR2_X0P5M_A9TR40
XXOR_12 xor_12 VDD VDD VSS VSS rvt_12 lvt_12 XOR2_X0P5M_A9TR40
XXOR_13 xor_13 VDD VDD VSS VSS rvt_13 lvt_13 XOR2_X0P5M_A9TR40
XXOR_14 xor_14 VDD VDD VSS VSS rvt_14 lvt_14 XOR2_X0P5M_A9TR40
XXOR_15 xor_15 VDD VDD VSS VSS rvt_15 lvt_15 XOR2_X0P5M_A9TR40
XXOR_16 xor_16 VDD VDD VSS VSS rvt_16 lvt_16 XOR2_X0P5M_A9TR40
XXOR_17 xor_17 VDD VDD VSS VSS rvt_17 lvt_17 XOR2_X0P5M_A9TR40
XXOR_18 xor_18 VDD VDD VSS VSS rvt_18 lvt_18 XOR2_X0P5M_A9TR40
XXOR_19 xor_19 VDD VDD VSS VSS rvt_19 lvt_19 XOR2_X0P5M_A9TR40
XXOR_20 xor_20 VDD VDD VSS VSS rvt_20 lvt_20 XOR2_X0P5M_A9TR40
XXOR_21 xor_21 VDD VDD VSS VSS rvt_21 lvt_21 XOR2_X0P5M_A9TR40
XXOR_22 xor_22 VDD VDD VSS VSS rvt_22 lvt_22 XOR2_X0P5M_A9TR40
XXOR_23 xor_23 VDD VDD VSS VSS rvt_23 lvt_23 XOR2_X0P5M_A9TR40
XXOR_24 xor_24 VDD VDD VSS VSS rvt_24 lvt_24 XOR2_X0P5M_A9TR40
XXOR_25 xor_25 VDD VDD VSS VSS rvt_25 lvt_25 XOR2_X0P5M_A9TR40
XXOR_26 xor_26 VDD VDD VSS VSS rvt_26 lvt_26 XOR2_X0P5M_A9TR40
XXOR_27 xor_27 VDD VDD VSS VSS rvt_27 lvt_27 XOR2_X0P5M_A9TR40
XXOR_28 xor_28 VDD VDD VSS VSS rvt_28 lvt_28 XOR2_X0P5M_A9TR40
XXOR_29 xor_29 VDD VDD VSS VSS rvt_29 lvt_29 XOR2_X0P5M_A9TR40
XMED_BUF_00 x1 VDD VDD VSS VSS xor_29 BUF_X0P7M_A9TL40
XMED_BUF_01 x2 VDD VDD VSS VSS x1 BUF_X0P7M_A9TL40
XMED_BUF_02 x3 VDD VDD VSS VSS x2 BUF_X0P7M_A9TL40
XMED_BUF_03 x4 VDD VDD VSS VSS x3 BUF_X0P7M_A9TL40
XMED_BUF_04 x5 VDD VDD VSS VSS x4 BUF_X0P7M_A9TL40
XMED_BUF_05 x6 VDD VDD VSS VSS x5 BUF_X0P7M_A9TL40
XMED_BUF_06 x7 VDD VDD VSS VSS x6 BUF_X0P7M_A9TL40
XMED_BUF_07 x8 VDD VDD VSS VSS x7 BUF_X0P7M_A9TL40
XMED_BUF_08 x9 VDD VDD VSS VSS x8 BUF_X0P7M_A9TL40
XMED_BUF_09 x10 VDD VDD VSS VSS x9 BUF_X0P7M_A9TL40
XMED_BUF_10 x11 VDD VDD VSS VSS x10 BUF_X0P7M_A9TL40
XMED_BUF_11 x12 VDD VDD VSS VSS x11 BUF_X0P7M_A9TL40
XMED_BUF_12 x13 VDD VDD VSS VSS x12 BUF_X0P7M_A9TL40
XMED_BUF_13 x14 VDD VDD VSS VSS x13 BUF_X0P7M_A9TL40
XMED_BUF_14 x15 VDD VDD VSS VSS x14 BUF_X0P7M_A9TL40
XMED_BUF_15 x16 VDD VDD VSS VSS x15 BUF_X0P7M_A9TL40
XMED_BUF_16 x17 VDD VDD VSS VSS x16 BUF_X0P7M_A9TL40
XMED_MUX_00 medium_out VDD VDD VSS VSS x1 my1 M0 MXT2_X0P5M_A9TL40
XMED_MUX_01 my1 VDD VDD VSS VSS x2 my2 M1 MXT2_X0P5M_A9TL40
XMED_MUX_02 my2 VDD VDD VSS VSS x3 my3 M2 MXT2_X0P5M_A9TL40
XMED_MUX_03 my3 VDD VDD VSS VSS x4 my4 M3 MXT2_X0P5M_A9TL40
XMED_MUX_04 my4 VDD VDD VSS VSS x5 my5 M4 MXT2_X0P5M_A9TL40
XMED_MUX_05 my5 VDD VDD VSS VSS x6 my6 M5 MXT2_X0P5M_A9TL40
XMED_MUX_06 my6 VDD VDD VSS VSS x7 my7 M6 MXT2_X0P5M_A9TL40
XMED_MUX_07 my7 VDD VDD VSS VSS x8 my8 M7 MXT2_X0P5M_A9TL40
XMED_MUX_08 my8 VDD VDD VSS VSS x9 my9 M8 MXT2_X0P5M_A9TL40
XMED_MUX_09 my9 VDD VDD VSS VSS x10 my10 M9 MXT2_X0P5M_A9TL40
XMED_MUX_10 my10 VDD VDD VSS VSS x11 my11 M10 MXT2_X0P5M_A9TL40
XMED_MUX_11 my11 VDD VDD VSS VSS x12 my12 M11 MXT2_X0P5M_A9TL40
XMED_MUX_12 my12 VDD VDD VSS VSS x13 my13 M12 MXT2_X0P5M_A9TL40
XMED_MUX_13 my13 VDD VDD VSS VSS x14 my14 M13 MXT2_X0P5M_A9TL40
XMED_MUX_14 my14 VDD VDD VSS VSS x15 my15 M14 MXT2_X0P5M_A9TL40
XMED_MUX_15 my15 VDD VDD VSS VSS x16 x17 M15 MXT2_X0P5M_A9TL40
XFINE_DRIVER dff_ck VDD VDD VSS VSS medium_out BUF_X0P8M_A9TL40
XLOAD_00 z_0 VDD VDD VSS VSS dff_ck F0 NOR2_X4A_A9TL40
XLOAD_01 z_1 VDD VDD VSS VSS dff_ck F1 NOR2_X4A_A9TL40
XLOAD_02 z_2 VDD VDD VSS VSS dff_ck F2 NOR2_X4A_A9TL40
XLOAD_03 z_3 VDD VDD VSS VSS dff_ck F3 NOR2_X4A_A9TL40
XLOAD_04 z_4 VDD VDD VSS VSS dff_ck F4 NOR2_X4A_A9TL40
XLOAD_05 z_5 VDD VDD VSS VSS dff_ck F5 NOR2_X4A_A9TL40
XLOAD_06 z_6 VDD VDD VSS VSS dff_ck F6 NOR2_X4A_A9TL40
XLOAD_07 z_7 VDD VDD VSS VSS dff_ck F7 NOR2_X4A_A9TL40
XLOAD_08 z_8 VDD VDD VSS VSS dff_ck F8 NOR2_X4A_A9TL40
XLOAD_09 z_9 VDD VDD VSS VSS dff_ck F9 NOR2_X4A_A9TL40
XDFF Q_FINAL VDD VDD VSS VSS dff_ck xor_29 S_RESET DFFRPQ_X0P5M_A9TR40
* MEDIUM rail M0 is controller port M0.
* MEDIUM rail M1 is controller port M1.
* MEDIUM rail M2 is controller port M2.
* MEDIUM rail M3 is controller port M3.
* MEDIUM rail M4 is controller port M4.
* MEDIUM rail M5 is controller port M5.
* MEDIUM rail M6 is controller port M6.
* MEDIUM rail M7 is controller port M7.
* MEDIUM rail M8 is controller port M8.
* MEDIUM rail M9 is controller port M9.
* MEDIUM rail M10 is controller port M10.
* MEDIUM rail M11 is controller port M11.
* MEDIUM rail M12 is controller port M12.
* MEDIUM rail M13 is controller port M13.
* MEDIUM rail M14 is controller port M14.
* MEDIUM rail M15 is controller port M15.
.ENDS FTC_SENSOR
