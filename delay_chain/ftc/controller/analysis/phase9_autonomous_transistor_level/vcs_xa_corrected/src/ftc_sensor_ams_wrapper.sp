* ============================================================================
* Corrected XA analog implementation of ftc_sensor_ams.
*
* VDD/VSS are local analog nodes, generated by ideal SPICE sources inside this
* subcircuit.  They are not Verilog ports and therefore cannot be converted by
* the generic digital-to-analog boundary.  VDD_VALUE is supplied by each
* scenario deck and is the only intended voltage difference between the three
* formal Phase 9 runs.
*
* The controller control ports remain ordinary XA crossings.  Their electrical
* levels and edge times are measured in R3 before any autonomous result is
* accepted; this wrapper does not silently tune a slew per M/F code.
* ============================================================================
.SUBCKT ftc_sensor_ams Q_FINAL sense_s_clk sense_dff_reset \
+ medium_therm[15] medium_therm[14] medium_therm[13] medium_therm[12] \
+ medium_therm[11] medium_therm[10] medium_therm[9] medium_therm[8] \
+ medium_therm[7] medium_therm[6] medium_therm[5] medium_therm[4] \
+ medium_therm[3] medium_therm[2] medium_therm[1] medium_therm[0] \
+ fine_therm[9] fine_therm[8] fine_therm[7] fine_therm[6] fine_therm[5] \
+ fine_therm[4] fine_therm[3] fine_therm[2] fine_therm[1] fine_therm[0]

* The explicit local sources are the only sensor supply drivers.  Each scenario
* deck must define VDD_VALUE as 0.80, 0.95, or 1.10 V before this subcircuit is
* elaborated; the wrapper does not provide a fallback that could hide a wrong
* scenario supply.
V_SENSOR_VDD VDD_LOCAL 0 VDD_VALUE
V_SENSOR_VSS VSS_LOCAL 0 0

XFTC_SENSOR Q_FINAL sense_s_clk sense_dff_reset \
+ medium_therm[15] medium_therm[14] medium_therm[13] medium_therm[12] \
+ medium_therm[11] medium_therm[10] medium_therm[9] medium_therm[8] \
+ medium_therm[7] medium_therm[6] medium_therm[5] medium_therm[4] \
+ medium_therm[3] medium_therm[2] medium_therm[1] medium_therm[0] \
+ fine_therm[9] fine_therm[8] fine_therm[7] fine_therm[6] fine_therm[5] \
+ fine_therm[4] fine_therm[3] fine_therm[2] fine_therm[1] fine_therm[0] \
+ VDD_LOCAL VSS_LOCAL FTC_SENSOR
.ENDS ftc_sensor_ams
